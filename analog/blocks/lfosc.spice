* rv328_lfosc : 128 kHz oscillator, always on (watchdog and low-frequency system clock)
*   Same principle as rv328_rcosc at about 1.5 uA: one resistor charges and discharges a capacitor
*   between 1/3 and 2/3 of the supply. No trim.
.subckt rv328_lfosc avdd vss clk
* Resistors are written as they are drawn: s equal strips in series.
.param lrt=133.5u
* thresholds (24 Mohm string)
xrd1 avdd vh vss ppolyf_u_1k_6p0 r_width=1u r_length=125u s=64
xrd2 vh  vl  vss ppolyf_u_1k_6p0 r_width=1u r_length=125u s=64
xrd3 vl  vss vss ppolyf_u_1k_6p0 r_width=1u r_length=125u s=64
* comparator bias, about 0.25 uA
xrb  avdd vbn vss ppolyf_u_1k_6p0 r_width=1u r_length=250u s=64
xmb1 vbn vbn vss vss nfet_06v0 w=2u l=4u
xmb2 vbpl vbn vss vss nfet_06v0 w=2u l=4u
xmb3 vbpl vbpl avdd avdd pfet_06v0 w=4u l=4u
* low comparator: lo1 is low while vc < vl
xlt tl vbpl avdd avdd pfet_06v0 w=4u l=4u
xl1 ln1 vc tl avdd pfet_06v0 w=4u l=1u
xl2 lo1 vl tl avdd pfet_06v0 w=4u l=1u
xl3 ln1 ln1 vss vss nfet_06v0 w=1u l=4u
xl4 lo1 ln1 vss vss nfet_06v0 w=1u l=4u
* second stage, current-limited. lo1 only swings between ground and about vl + 1 V, so it
* drives an NMOS: s2 is high while vc < vl
xls1 s2 lo1 vss vss nfet_06v0 w=1u l=1u
xls2 s2 vbpl avdd avdd pfet_06v0 w=4u l=4u
xls3 avdd vss s2 setb rv328_invw
* high comparator: ho1 is high while vc > vh
xht th vbn vss vss nfet_06v0 w=2u l=4u
xh1 hn1 vc th vss nfet_06v0 w=2u l=1u
xh2 ho1 vh th vss nfet_06v0 w=2u l=1u
xh3 hn1 hn1 avdd avdd pfet_06v0 w=2u l=4u
xh4 ho1 hn1 avdd avdd pfet_06v0 w=2u l=4u
* second stage, current-limited. ho1 only swings between about vh - 1 V and the supply, so it
* drives a PMOS: r2 is high while vc < vh
xhs1 r2 ho1 avdd avdd pfet_06v0 w=1u l=1u
xhs2 r2 vbn vss vss nfet_06v0 w=2u l=4u
xhs3 avdd vss r2 r3 rv328_invw
xhs4 avdd vss r3 rstb rv328_invw
* latch: setb low sets q, rstb low clears it
xq1 avdd vss setb qb q rv328_nand2
xq2 avdd vss rstb q qb rv328_nand2
* driver, timing resistor (44 strips of 133 um, 2 Mohm) and capacitor (2 pF)
xd1 avdd vss q d1 rv328_inv
xd2 avdd vss d1 drv rv328_inv wp=4u wn=2u
xrt drv vc vss ppolyf_u r_width=1u r_length=lrt s=37
xct vc vss cap_mim_2f0fF c_width=31.1u c_length=31.1u
xo1 avdd vss q ob rv328_inv
xo2 avdd vss ob clk rv328_inv wp=4u wn=2u
.ends
