* rv328_adcfe with the wiring capacitance of its layout. Written by analog/layout/pex_block.py from rv328_adcfe.gds;
* same cell name and pins as the schematic. 3963 wiring capacitors, no wiring resistance;
* 1453 transistor fingers; groups of 9 or more identical parallel ones are one line with m=.
* NGSPICE file created from rv328_adcfe.ext - technology: gf180mcuD

.subckt rv328_adcfe avdd vss ain vrefp sample d9 d8 d7 d6 d5 d4 d3 d2 d1 d0 vbp en cmp
X0 b9 bsb ain avdd pfet_06v0 ad=2.24p pd=8.56u as=2.24p ps=8.56u w=8u l=0.55u m=126
X5 ain bsb b9 avdd pfet_06v0 ad=2.24p pd=8.56u as=4p ps=17u w=8u l=0.55u
X45 b9 bsb ain avdd pfet_06v0 ad=4p pd=17u as=2.24p ps=8.56u w=8u l=0.55u
X128 ain bs b9 vss nfet_06v0 ad=2.24p pd=8.56u as=4p ps=17u w=8u l=0.7u
X129 ain bs b9 vss nfet_06v0 ad=2.24p pd=8.56u as=2.24p ps=8.56u w=8u l=0.7u m=62
X132 b9 bs ain vss nfet_06v0 ad=4p pd=17u as=2.24p ps=8.56u w=8u l=0.7u
X192 ain bs b8 vss nfet_06v0 ad=2.24p pd=8.56u as=4p ps=17u w=8u l=0.7u
X193 ain bs b8 vss nfet_06v0 ad=2.24p pd=8.56u as=2.24p ps=8.56u w=8u l=0.7u m=30
X214 b8 bs ain vss nfet_06v0 ad=4p pd=17u as=2.24p ps=8.56u w=8u l=0.7u
X224 b9 sg9 vss vss nfet_06v0 ad=2.24p pd=8.56u as=4p ps=17u w=8u l=1.4u
X225 vss sg9 b9 vss nfet_06v0 ad=2.24p pd=8.56u as=2.24p ps=8.56u w=8u l=1.4u m=30
X254 vss sg9 b9 vss nfet_06v0 ad=4p pd=17u as=2.24p ps=8.56u w=8u l=1.4u
X256 vrefp sr9 b9 vss nfet_06v0 ad=0.14597n pd=0.56508m as=0.29376n ps=1.12944m w=8u l=1.4u
X257 b9 sr9 vrefp vss nfet_06v0 ad=0 pd=0 as=0 ps=0 w=8u l=1.4u m=31
X288 ain bsb b8 avdd pfet_06v0 ad=2.24p pd=8.56u as=4p ps=17u w=8u l=0.55u
X289 b8 bsb ain avdd pfet_06v0 ad=2.24p pd=8.56u as=2.24p ps=8.56u w=8u l=0.55u m=62
X337 b8 bsb ain avdd pfet_06v0 ad=4p pd=17u as=2.24p ps=8.56u w=8u l=0.55u
X352 vrefp rb9 b9 avdd pfet_06v0 ad=2.24p pd=8.56u as=4p ps=17u w=8u l=1.2u
X353 b9 rb9 vrefp avdd pfet_06v0 ad=2.24p pd=8.56u as=2.24p ps=8.56u w=8u l=1.2u m=62
X374 b9 rb9 vrefp avdd pfet_06v0 ad=4p pd=17u as=2.24p ps=8.56u w=8u l=1.2u
X416 xcmp_vbi en avdd avdd pfet_06v0 ad=0.5p pd=3u as=0.5p ps=3u w=1u l=0.6u
X417 cmp xcmp_o3 vss vss nfet_06v0 ad=1p pd=5u as=1p ps=5u w=2u l=0.7u
X418 xcmp_d1 azc vss vss nfet_06v0 ad=1p pd=5u as=0.32768n ps=1.55312m w=2u l=0.7u
X419 xcmp_o2 xcmp_enb vss vss nfet_06v0 ad=0.5p pd=3u as=0.5p ps=3u w=1u l=0.7u
X420 xcmp_o3 xcmp_o2 vss vss nfet_06v0 ad=0.5p pd=3u as=0 ps=0 w=1u l=0.7u
X421 xcmp_enb en vss vss nfet_06v0 ad=0.5p pd=3u as=0 ps=0 w=1u l=0.7u
X422 xcmp_a dum xcmp_tail avdd pfet_06v0 ad=2.8p pd=10.56u as=5p ps=21u w=10u l=2u
X423 xcmp_a dum xcmp_tail avdd pfet_06v0 ad=2.8p pd=10.56u as=2.8p ps=10.56u w=10u l=2u
X424 xcmp_a dum xcmp_tail avdd pfet_06v0 ad=2.8p pd=10.56u as=2.8p ps=10.56u w=10u l=2u
X425 xcmp_tail dum xcmp_a avdd pfet_06v0 ad=2.8p pd=10.56u as=2.8p ps=10.56u w=10u l=2u
X426 xcmp_tail dum xcmp_a avdd pfet_06v0 ad=5p pd=21u as=2.8p ps=10.56u w=10u l=2u
X427 xcmp_tail dum xcmp_a avdd pfet_06v0 ad=2.8p pd=10.56u as=2.8p ps=10.56u w=10u l=2u
X428 xcmp_a dum xcmp_tail avdd pfet_06v0 ad=2.8p pd=10.56u as=2.8p ps=10.56u w=10u l=2u
X429 xcmp_tail dum xcmp_a avdd pfet_06v0 ad=2.8p pd=10.56u as=2.8p ps=10.56u w=10u l=2u
X430 xcmp_x azc xcmp_xm vss nfet_06v0 ad=0.25p pd=2u as=0.25p ps=2u w=0.5u l=0.7u
X431 vbp en xcmp_vbi vss nfet_06v0 ad=0.5p pd=3u as=0.5p ps=3u w=1u l=0.7u
X432 xcmp_b top xcmp_tail avdd pfet_06v0 ad=22.4p pd=84.48u as=71.52p ps=0.27696m w=10u l=2u
X433 xcmp_b top xcmp_tail avdd pfet_06v0 ad=0 pd=0 as=0 ps=0 w=10u l=2u
X434 xcmp_b top xcmp_tail avdd pfet_06v0 ad=0 pd=0 as=0 ps=0 w=10u l=2u
X435 xcmp_tail top xcmp_b avdd pfet_06v0 ad=0 pd=0 as=0 ps=0 w=10u l=2u
X436 xcmp_tail top xcmp_b avdd pfet_06v0 ad=0 pd=0 as=0 ps=0 w=10u l=2u
X437 xcmp_tail top xcmp_b avdd pfet_06v0 ad=0 pd=0 as=0 ps=0 w=10u l=2u
X438 xcmp_b top xcmp_tail avdd pfet_06v0 ad=0 pd=0 as=0 ps=0 w=10u l=2u
X439 xcmp_tail top xcmp_b avdd pfet_06v0 ad=0 pd=0 as=0 ps=0 w=10u l=2u
X440 xcmp_xm azc xcmp_vb vss nfet_06v0 ad=0.75p pd=6u as=2.75p ps=15u w=0.5u l=0.7u
X441 xcmp_xm xcmp_azn xcmp_vb vss nfet_06v0 ad=0 pd=0 as=0 ps=0 w=0.5u l=0.7u
X442 xcmp_y azc xcmp_ym vss nfet_06v0 ad=0.25p pd=2u as=0.75p ps=6u w=0.5u l=0.7u
X443 xcmp_ym azc xcmp_o1 vss nfet_06v0 ad=0 pd=0 as=6.25p ps=28u w=0.5u l=0.7u
X444 xcmp_ym xcmp_azn xcmp_vb vss nfet_06v0 ad=0 pd=0 as=0 ps=0 w=0.5u l=0.7u
X445 xcmp_n1 xcmp_x xcmp_tail2 avdd pfet_06v0 ad=2.8p pd=10.56u as=5p ps=21u w=10u l=2u
X446 xcmp_n1 xcmp_x xcmp_tail2 avdd pfet_06v0 ad=2.8p pd=10.56u as=2.8p ps=10.56u w=10u l=2u
X447 xcmp_tail2 xcmp_x xcmp_n1 avdd pfet_06v0 ad=2.8p pd=10.56u as=2.8p ps=10.56u w=10u l=2u
X448 xcmp_tail2 xcmp_x xcmp_n1 avdd pfet_06v0 ad=5p pd=21u as=2.8p ps=10.56u w=10u l=2u
X449 xcmp_tail xcmp_vbi avdd avdd pfet_06v0 ad=4.48p pd=16.56u as=8p ps=33u w=16u l=8u
X450 avdd xcmp_vbi xcmp_tail avdd pfet_06v0 ad=4.48p pd=16.56u as=4.48p ps=16.56u w=16u l=8u
X451 xcmp_tail xcmp_vbi avdd avdd pfet_06v0 ad=4.48p pd=16.56u as=4.48p ps=16.56u w=16u l=8u
X452 avdd xcmp_vbi xcmp_tail avdd pfet_06v0 ad=8p pd=33u as=4.48p ps=16.56u w=16u l=8u
X453 xcmp_n1 xcmp_n1 vss vss nfet_06v0 ad=4p pd=17u as=4p ps=17u w=8u l=4u
X454 xcmp_azn azc vss vss nfet_06v0 ad=0.25p pd=2u as=0 ps=0 w=0.5u l=0.7u
X455 xcmp_d1 vss cap_mim_2f0_m4m5_noshield c_width=10u c_length=10u
X456 xcmp_o1 xcmp_y xcmp_tail2 avdd pfet_06v0 ad=11.2p pd=42.24u as=40.16p ps=0.15936m w=10u l=2u
X457 xcmp_o1 xcmp_y xcmp_tail2 avdd pfet_06v0 ad=0 pd=0 as=0 ps=0 w=10u l=2u
X458 xcmp_tail2 xcmp_y xcmp_o1 avdd pfet_06v0 ad=0 pd=0 as=0 ps=0 w=10u l=2u
X459 xcmp_tail2 xcmp_y xcmp_o1 avdd pfet_06v0 ad=0 pd=0 as=0 ps=0 w=10u l=2u
X460 cmp xcmp_o3 avdd avdd pfet_06v0 ad=2p pd=9u as=2p ps=9u w=4u l=0.55u
X461 xcmp_azd vss cap_mim_2f0_m4m5_noshield c_width=10u c_length=10u
X462 xcmp_o1 xcmp_n1 vss vss nfet_06v0 ad=0 pd=0 as=0 ps=0 w=8u l=4u
X463 vbp xcmp_enb xcmp_vbi avdd pfet_06v0 ad=1p pd=5u as=1p ps=5u w=2u l=0.55u
X464 xcmp_tail2 xcmp_vbi avdd avdd pfet_06v0 ad=4.48p pd=16.56u as=8p ps=33u w=16u l=8u
X465 avdd xcmp_vbi xcmp_tail2 avdd pfet_06v0 ad=8p pd=33u as=4.48p ps=16.56u w=16u l=8u
X466 xcmp_enb en avdd avdd pfet_06v0 ad=1p pd=5u as=0.31468n ps=1.47431m w=2u l=0.55u
X467 xcmp_azn azc avdd avdd pfet_06v0 ad=0.5p pd=3u as=0.5p ps=3u w=1u l=0.55u
X468 xcmp_vb xcmp_vbi avdd avdd pfet_06v0 ad=8.96p pd=33.12u as=0 ps=0 w=16u l=8u
X469 avdd xcmp_vbi xcmp_vb avdd pfet_06v0 ad=0 pd=0 as=0 ps=0 w=16u l=8u
X470 xcmp_o2 xcmp_vbi avdd avdd pfet_06v0 ad=8.96p pd=33.12u as=0 ps=0 w=16u l=8u
X471 avdd xcmp_vbi xcmp_o2 avdd pfet_06v0 ad=0 pd=0 as=0 ps=0 w=16u l=8u
X472 xcmp_o3 xcmp_o2 avdd avdd pfet_06v0 ad=1p pd=5u as=0 ps=0 w=2u l=0.55u
X473 xcmp_azd xcmp_d1 avdd avdd pfet_06v0 ad=1p pd=5u as=0 ps=0 w=2u l=0.55u
X474 xcmp_d1 azc avdd avdd pfet_06v0 ad=0.25p pd=2u as=0.25p ps=2u w=0.5u l=8u
X475 xcmp_vb xcmp_vb vss vss nfet_06v0 ad=2p pd=9u as=2p ps=9u w=4u l=1u
X476 xcmp_vb vss cap_mim_2f0_m4m5_noshield c_width=22u c_length=22u
X477 xcmp_o2 xcmp_o1 vss vss nfet_06v0 ad=2.5p pd=12u as=0 ps=0 w=4u l=1u
X478 xcmp_a xcmp_x cap_mim_2f0_m4m5_noshield c_width=22u c_length=22u
X479 xcmp_azd xcmp_d1 vss vss nfet_06v0 ad=0.25p pd=2u as=0.25p ps=2u w=0.5u l=8u
X480 xcmp_b xcmp_y cap_mim_2f0_m4m5_noshield c_width=22u c_length=22u
X481 xcmp_a vss vss ppolyf_u_1k_6p0 r_width=1u r_length=60u
X482 xcmp_oc vss cap_mim_2f0_m4m5_noshield c_width=22u c_length=22u
X483 xcmp_b vss vss ppolyf_u_1k_6p0 r_width=1u r_length=60u
X484 xcmp_o1 xcmp_azd xcmp_oc vss nfet_06v0 ad=2p pd=9u as=2p ps=9u w=4u l=0.7u
X485 q2 vss cap_mim_2f0_m4m5_noshield c_width=7u c_length=7u
X486 azb dn xds_n1 avdd pfet_06v0 ad=2p pd=9u as=2p ps=9u w=4u l=1u
X487 q2 q1 vss vss nfet_06v0 ad=0.25p pd=2u as=0 ps=0 w=0.5u l=0.7u
X488 q1 vss cap_mim_2f0_m4m5_noshield c_width=7u c_length=7u
X489 xds_n1 dn avdd avdd pfet_06v0 ad=5p pd=23u as=0 ps=0 w=4u l=1u
X490 q1 hs vss vss nfet_06v0 ad=0.25p pd=2u as=0 ps=0 w=0.5u l=0.7u
X491 a d1b vss vss nfet_06v0 ad=0.25p pd=2u as=0 ps=0 w=0.5u l=0.7u
X492 azb dn xds_n2 vss nfet_06v0 ad=1p pd=5u as=1p ps=5u w=2u l=1u
X493 xds_n2 dn vss vss nfet_06v0 ad=2.5p pd=13u as=0 ps=0 w=2u l=1u
X494 azc vss cap_mim_2f0_m4m5_noshield c_width=10u c_length=10u
X495 q2 q1 avdd avdd pfet_06v0 ad=0.5p pd=3u as=0 ps=0 w=1u l=0.55u
X496 d1b azc vss vss nfet_06v0 ad=4p pd=17u as=4p ps=17u w=8u l=0.7u
X497 q1 hs avdd avdd pfet_06v0 ad=0.5p pd=3u as=0 ps=0 w=1u l=0.55u
X498 a d1b avdd avdd pfet_06v0 ad=0.5p pd=3u as=0 ps=0 w=1u l=0.55u
X499 xds_n2 azb avdd vss nfet_06v0 ad=0.5p pd=3u as=0.5p ps=3u w=1u l=1u
X500 d1b azc avdd avdd pfet_06v0 ad=0.25p pd=2u as=0.25p ps=2u w=0.5u l=4u
X501 dn vss cap_mim_2f0_m4m5_noshield c_width=22u c_length=22u
X502 azc azn vss vss nfet_06v0 ad=0.25p pd=2u as=0 ps=0 w=0.5u l=8u
X503 xds_n1 azb vss avdd pfet_06v0 ad=1p pd=5u as=1p ps=5u w=2u l=1u
X504 rv328_adcfe_p1_0/res1k_l60_n20_w1_0/a_n128_5100# rv328_adcfe_p1_0/res1k_l60_n20_w1_0/a_12000_5400# vss ppolyf_u_1k_6p0 r_width=1u r_length=60u
X505 rv328_adcfe_p1_0/res1k_l60_n20_w1_0/a_n128_2100# rv328_adcfe_p1_0/res1k_l60_n20_w1_0/a_12000_1800# vss ppolyf_u_1k_6p0 r_width=1u r_length=60u
X506 dn rv328_adcfe_p1_0/res1k_l60_n20_w1_0/a_12000_5400# vss ppolyf_u_1k_6p0 r_width=1u r_length=60u
X507 rv328_adcfe_p1_0/res1k_l60_n20_w1_0/a_n128_2100# rv328_adcfe_p1_0/res1k_l60_n20_w1_0/a_12000_2400# vss ppolyf_u_1k_6p0 r_width=1u r_length=60u
X508 rv328_adcfe_p1_0/res1k_l60_n20_w1_0/a_n128_2700# rv328_adcfe_p1_0/res1k_l60_n20_w1_0/a_12000_2400# vss ppolyf_u_1k_6p0 r_width=1u r_length=60u
X509 rv328_adcfe_p1_0/res1k_l60_n20_w1_0/a_n128_2700# rv328_adcfe_p1_0/res1k_l60_n20_w1_0/a_12000_3000# vss ppolyf_u_1k_6p0 r_width=1u r_length=60u
X510 rv328_adcfe_p1_0/res1k_l60_n20_w1_0/a_n128_300# rv328_adcfe_p1_0/res1k_l60_n20_w1_0/a_12000_0# vss ppolyf_u_1k_6p0 r_width=1u r_length=60u
X511 rv328_adcfe_p1_0/res1k_l60_n20_w1_0/a_n128_3300# rv328_adcfe_p1_0/res1k_l60_n20_w1_0/a_12000_3000# vss ppolyf_u_1k_6p0 r_width=1u r_length=60u
X512 rv328_adcfe_p1_0/res1k_l60_n20_w1_0/a_n128_3300# rv328_adcfe_p1_0/res1k_l60_n20_w1_0/a_12000_3600# vss ppolyf_u_1k_6p0 r_width=1u r_length=60u
X513 rv328_adcfe_p1_0/res1k_l60_n20_w1_0/a_n128_300# rv328_adcfe_p1_0/res1k_l60_n20_w1_0/a_12000_600# vss ppolyf_u_1k_6p0 r_width=1u r_length=60u
X514 rv328_adcfe_p1_0/res1k_l60_n20_w1_0/a_n128_900# rv328_adcfe_p1_0/res1k_l60_n20_w1_0/a_12000_600# vss ppolyf_u_1k_6p0 r_width=1u r_length=60u
X515 rv328_adcfe_p1_0/res1k_l60_n20_w1_0/a_n128_3900# rv328_adcfe_p1_0/res1k_l60_n20_w1_0/a_12000_3600# vss ppolyf_u_1k_6p0 r_width=1u r_length=60u
X516 rv328_adcfe_p1_0/res1k_l60_n20_w1_0/a_n128_3900# rv328_adcfe_p1_0/res1k_l60_n20_w1_0/a_12000_4200# vss ppolyf_u_1k_6p0 r_width=1u r_length=60u
X517 rv328_adcfe_p1_0/res1k_l60_n20_w1_0/a_n128_4500# rv328_adcfe_p1_0/res1k_l60_n20_w1_0/a_12000_4200# vss ppolyf_u_1k_6p0 r_width=1u r_length=60u
X518 rv328_adcfe_p1_0/res1k_l60_n20_w1_0/a_n128_900# rv328_adcfe_p1_0/res1k_l60_n20_w1_0/a_12000_1200# vss ppolyf_u_1k_6p0 r_width=1u r_length=60u
X519 rv328_adcfe_p1_0/res1k_l60_n20_w1_0/a_n128_4500# rv328_adcfe_p1_0/res1k_l60_n20_w1_0/a_12000_4800# vss ppolyf_u_1k_6p0 r_width=1u r_length=60u
X520 rv328_adcfe_p1_0/res1k_l60_n20_w1_0/a_n128_1500# rv328_adcfe_p1_0/res1k_l60_n20_w1_0/a_12000_1200# vss ppolyf_u_1k_6p0 r_width=1u r_length=60u
X521 rv328_adcfe_p1_0/res1k_l60_n20_w1_0/a_n128_1500# rv328_adcfe_p1_0/res1k_l60_n20_w1_0/a_12000_1800# vss ppolyf_u_1k_6p0 r_width=1u r_length=60u
X522 ts rv328_adcfe_p1_0/res1k_l60_n20_w1_0/a_12000_0# vss ppolyf_u_1k_6p0 r_width=1u r_length=60u
X523 rv328_adcfe_p1_0/res1k_l60_n20_w1_0/a_n128_5100# rv328_adcfe_p1_0/res1k_l60_n20_w1_0/a_12000_4800# vss ppolyf_u_1k_6p0 r_width=1u r_length=60u
X524 a vss cap_mim_2f0_m4m5_noshield c_width=5u c_length=5u
X525 azc azn avdd avdd pfet_06v0 ad=1p pd=5u as=1p ps=5u w=2u l=0.6u
X526 d1b vss cap_mim_2f0_m4m5_noshield c_width=5u c_length=5u
X527 vrefp rb8 b8 avdd pfet_06v0 ad=2.24p pd=8.56u as=4p ps=17u w=8u l=1.2u
X528 b8 rb8 vrefp avdd pfet_06v0 ad=4p pd=17u as=2.24p ps=8.56u w=8u l=1.2u
X529 vrefp rb8 b8 avdd pfet_06v0 ad=2.24p pd=8.56u as=2.24p ps=8.56u w=8u l=1.2u m=30
X559 ain bs b4 vss nfet_06v0 ad=2.24p pd=8.56u as=4p ps=17u w=8u l=0.7u
X560 b4 bs ain vss nfet_06v0 ad=4p pd=17u as=2.24p ps=8.56u w=8u l=0.7u
X561 ain bsb b6 avdd pfet_06v0 ad=2.24p pd=8.56u as=4p ps=17u w=8u l=0.55u
X562 b6 bsb ain avdd pfet_06v0 ad=2.24p pd=8.56u as=2.24p ps=8.56u w=8u l=0.55u m=14
X567 b6 bsb ain avdd pfet_06v0 ad=4p pd=17u as=2.24p ps=8.56u w=8u l=0.55u
X577 bx hsg vss vss nfet_06v0 ad=0.25p pd=2u as=0.25p ps=2u w=0.5u l=1.4u
X578 b0 sg0 vss vss nfet_06v0 ad=1p pd=7u as=0 ps=0 w=0.5u l=1.4u
X579 vrefp sr0 b0 vss nfet_06v0 ad=0 pd=0 as=0 ps=0 w=0.5u l=1.4u
X580 vrefp rb7 b7 avdd pfet_06v0 ad=2.24p pd=8.56u as=4p ps=17u w=8u l=1.2u
X581 vrefp rb7 b7 avdd pfet_06v0 ad=2.24p pd=8.56u as=2.24p ps=8.56u w=8u l=1.2u m=14
X588 b7 rb7 vrefp avdd pfet_06v0 ad=4p pd=17u as=2.24p ps=8.56u w=8u l=1.2u
X596 ain bs b0 vss nfet_06v0 ad=0.28892n pd=1.11092m as=0 ps=0 w=1u l=0.7u
X597 ain bs bx vss nfet_06v0 ad=0 pd=0 as=0.75p ps=5u w=1u l=0.7u
X598 vrefp rb3 b3 avdd pfet_06v0 ad=4p pd=17u as=4p ps=17u w=8u l=1.2u
X599 vrefp rb2 b2 avdd pfet_06v0 ad=0.28p pd=1.56u as=0.5p ps=3u w=1u l=1.2u
X600 vrefp rb2 b2 avdd pfet_06v0 ad=0.28p pd=1.56u as=0.28p ps=1.56u w=1u l=1.2u
X601 b2 rb2 vrefp avdd pfet_06v0 ad=0.5p pd=3u as=0.28p ps=1.56u w=1u l=1.2u
X602 b2 rb2 vrefp avdd pfet_06v0 ad=0.28p pd=1.56u as=0.28p ps=1.56u w=1u l=1.2u
X603 vrefp rb1 b1 avdd pfet_06v0 ad=0.28p pd=1.56u as=0.5p ps=3u w=1u l=1.2u
X604 b1 rb1 vrefp avdd pfet_06v0 ad=0.5p pd=3u as=0.28p ps=1.56u w=1u l=1.2u
X605 b4 sg4 vss vss nfet_06v0 ad=4p pd=17u as=4p ps=17u w=8u l=1.4u
X606 vrefp sr4 b4 vss nfet_06v0 ad=0 pd=0 as=16p ps=68u w=8u l=1.4u
X607 b2 sg2 vss vss nfet_06v0 ad=0.14p pd=1.06u as=0.25p ps=2u w=0.5u l=1.4u
X608 vss sg2 b2 vss nfet_06v0 ad=0.25p pd=2u as=0.14p ps=1.06u w=0.5u l=1.4u
X609 vss sg2 b2 vss nfet_06v0 ad=0.14p pd=1.06u as=0.14p ps=1.06u w=0.5u l=1.4u
X610 b2 sg2 vss vss nfet_06v0 ad=0.14p pd=1.06u as=0.14p ps=1.06u w=0.5u l=1.4u
X611 vrefp rb6 b6 avdd pfet_06v0 ad=2.24p pd=8.56u as=4p ps=17u w=8u l=1.2u
X612 vrefp rb6 b6 avdd pfet_06v0 ad=2.24p pd=8.56u as=2.24p ps=8.56u w=8u l=1.2u
X613 b6 rb6 vrefp avdd pfet_06v0 ad=2.24p pd=8.56u as=2.24p ps=8.56u w=8u l=1.2u
X614 b6 rb6 vrefp avdd pfet_06v0 ad=2.24p pd=8.56u as=2.24p ps=8.56u w=8u l=1.2u
X615 b6 rb6 vrefp avdd pfet_06v0 ad=4p pd=17u as=2.24p ps=8.56u w=8u l=1.2u
X616 vrefp rb6 b6 avdd pfet_06v0 ad=2.24p pd=8.56u as=2.24p ps=8.56u w=8u l=1.2u
X617 b6 rb6 vrefp avdd pfet_06v0 ad=2.24p pd=8.56u as=2.24p ps=8.56u w=8u l=1.2u
X618 vrefp rb6 b6 avdd pfet_06v0 ad=2.24p pd=8.56u as=2.24p ps=8.56u w=8u l=1.2u
X619 ain bsb bx avdd pfet_06v0 ad=0.57432n pd=2.1996m as=1p ps=5u w=2u l=0.55u
X620 vrefp sr2 b2 vss nfet_06v0 ad=0 pd=0 as=2.9p ps=19.48u w=0.5u l=1.4u
X621 b2 sr2 vrefp vss nfet_06v0 ad=0 pd=0 as=0 ps=0 w=0.5u l=1.4u
X622 b2 sr2 vrefp vss nfet_06v0 ad=0 pd=0 as=0 ps=0 w=0.5u l=1.4u
X623 vrefp sr2 b2 vss nfet_06v0 ad=0 pd=0 as=0 ps=0 w=0.5u l=1.4u
X624 ain bs b3 vss nfet_06v0 ad=0 pd=0 as=8p ps=35u w=8u l=0.7u
X625 ain bsb b0 avdd pfet_06v0 ad=0 pd=0 as=1.5p ps=8u w=2u l=0.55u
X626 ain bs b2 vss nfet_06v0 ad=0.28p pd=1.56u as=0.5p ps=3u w=1u l=0.7u
X627 b2 bs ain vss nfet_06v0 ad=0.5p pd=3u as=0.28p ps=1.56u w=1u l=0.7u
X628 b2 bs ain vss nfet_06v0 ad=0.28p pd=1.56u as=0.28p ps=1.56u w=1u l=0.7u
X629 ain bs b2 vss nfet_06v0 ad=0.28p pd=1.56u as=0.28p ps=1.56u w=1u l=0.7u
X630 b1 sg1 vss vss nfet_06v0 ad=0.14p pd=1.06u as=0.25p ps=2u w=0.5u l=1.4u
X631 vss sg1 b1 vss nfet_06v0 ad=0.25p pd=2u as=0.14p ps=1.06u w=0.5u l=1.4u
X632 ain bsb b5 avdd pfet_06v0 ad=2.24p pd=8.56u as=4p ps=17u w=8u l=0.55u
X633 b5 bsb ain avdd pfet_06v0 ad=2.24p pd=8.56u as=2.24p ps=8.56u w=8u l=0.55u
X634 ain bsb b5 avdd pfet_06v0 ad=2.24p pd=8.56u as=2.24p ps=8.56u w=8u l=0.55u
X635 ain bsb b5 avdd pfet_06v0 ad=2.24p pd=8.56u as=2.24p ps=8.56u w=8u l=0.55u
X636 b5 bsb ain avdd pfet_06v0 ad=2.24p pd=8.56u as=2.24p ps=8.56u w=8u l=0.55u
X637 b5 bsb ain avdd pfet_06v0 ad=2.24p pd=8.56u as=2.24p ps=8.56u w=8u l=0.55u
X638 ain bsb b5 avdd pfet_06v0 ad=2.24p pd=8.56u as=2.24p ps=8.56u w=8u l=0.55u
X639 b5 bsb ain avdd pfet_06v0 ad=4p pd=17u as=2.24p ps=8.56u w=8u l=0.55u
X640 ain bs b7 vss nfet_06v0 ad=2.24p pd=8.56u as=4p ps=17u w=8u l=0.7u
X641 ain bs b7 vss nfet_06v0 ad=2.24p pd=8.56u as=2.24p ps=8.56u w=8u l=0.7u m=14
X654 b7 bs ain vss nfet_06v0 ad=4p pd=17u as=2.24p ps=8.56u w=8u l=0.7u
X656 b7 sg7 vss vss nfet_06v0 ad=2.24p pd=8.56u as=4p ps=17u w=8u l=1.4u
X657 vss sg7 b7 vss nfet_06v0 ad=4p pd=17u as=2.24p ps=8.56u w=8u l=1.4u
X658 vss sg7 b7 vss nfet_06v0 ad=2.24p pd=8.56u as=2.24p ps=8.56u w=8u l=1.4u
X659 vss sg7 b7 vss nfet_06v0 ad=2.24p pd=8.56u as=2.24p ps=8.56u w=8u l=1.4u
X660 b7 sg7 vss vss nfet_06v0 ad=2.24p pd=8.56u as=2.24p ps=8.56u w=8u l=1.4u
X661 b7 sg7 vss vss nfet_06v0 ad=2.24p pd=8.56u as=2.24p ps=8.56u w=8u l=1.4u
X662 vss sg7 b7 vss nfet_06v0 ad=2.24p pd=8.56u as=2.24p ps=8.56u w=8u l=1.4u
X663 b7 sg7 vss vss nfet_06v0 ad=2.24p pd=8.56u as=2.24p ps=8.56u w=8u l=1.4u
X664 vrefp sr7 b7 vss nfet_06v0 ad=0 pd=0 as=78.71999p ps=0.30768m w=8u l=1.4u
X665 b7 sr7 vrefp vss nfet_06v0 ad=0 pd=0 as=0 ps=0 w=8u l=1.4u
X666 b7 sr7 vrefp vss nfet_06v0 ad=0 pd=0 as=0 ps=0 w=8u l=1.4u
X667 b7 sr7 vrefp vss nfet_06v0 ad=0 pd=0 as=0 ps=0 w=8u l=1.4u
X668 vrefp sr7 b7 vss nfet_06v0 ad=0 pd=0 as=0 ps=0 w=8u l=1.4u
X669 vrefp sr7 b7 vss nfet_06v0 ad=0 pd=0 as=0 ps=0 w=8u l=1.4u
X670 b7 sr7 vrefp vss nfet_06v0 ad=0 pd=0 as=0 ps=0 w=8u l=1.4u
X671 vrefp sr7 b7 vss nfet_06v0 ad=0 pd=0 as=0 ps=0 w=8u l=1.4u
X672 vrefp sr1 b1 vss nfet_06v0 ad=0 pd=0 as=1.78p ps=12.12u w=0.5u l=1.4u
X673 b1 sr1 vrefp vss nfet_06v0 ad=0 pd=0 as=0 ps=0 w=0.5u l=1.4u
X674 ain bs b1 vss nfet_06v0 ad=0.28p pd=1.56u as=0.5p ps=3u w=1u l=0.7u
X675 b1 bs ain vss nfet_06v0 ad=0.5p pd=3u as=0.28p ps=1.56u w=1u l=0.7u
X676 vrefp rb5 b5 avdd pfet_06v0 ad=2.24p pd=8.56u as=4p ps=17u w=8u l=1.2u
X677 vrefp rb5 b5 avdd pfet_06v0 ad=2.24p pd=8.56u as=2.24p ps=8.56u w=8u l=1.2u
X678 b5 rb5 vrefp avdd pfet_06v0 ad=4p pd=17u as=2.24p ps=8.56u w=8u l=1.2u
X679 b5 rb5 vrefp avdd pfet_06v0 ad=2.24p pd=8.56u as=2.24p ps=8.56u w=8u l=1.2u
X680 vrefp rb4 b4 avdd pfet_06v0 ad=2.24p pd=8.56u as=4p ps=17u w=8u l=1.2u
X681 b4 rb4 vrefp avdd pfet_06v0 ad=4p pd=17u as=2.24p ps=8.56u w=8u l=1.2u
X682 ain bs b6 vss nfet_06v0 ad=2.24p pd=8.56u as=4p ps=17u w=8u l=0.7u
X683 b6 bs ain vss nfet_06v0 ad=2.24p pd=8.56u as=2.24p ps=8.56u w=8u l=0.7u
X684 b6 bs ain vss nfet_06v0 ad=4p pd=17u as=2.24p ps=8.56u w=8u l=0.7u
X685 b6 bs ain vss nfet_06v0 ad=2.24p pd=8.56u as=2.24p ps=8.56u w=8u l=0.7u
X686 b6 bs ain vss nfet_06v0 ad=2.24p pd=8.56u as=2.24p ps=8.56u w=8u l=0.7u
X687 ain bs b6 vss nfet_06v0 ad=2.24p pd=8.56u as=2.24p ps=8.56u w=8u l=0.7u
X688 ain bs b6 vss nfet_06v0 ad=2.24p pd=8.56u as=2.24p ps=8.56u w=8u l=0.7u
X689 ain bs b6 vss nfet_06v0 ad=2.24p pd=8.56u as=2.24p ps=8.56u w=8u l=0.7u
X690 ain bsb b4 avdd pfet_06v0 ad=2.24p pd=8.56u as=4p ps=17u w=8u l=0.55u
X691 b4 bsb ain avdd pfet_06v0 ad=4p pd=17u as=2.24p ps=8.56u w=8u l=0.55u
X692 ain bsb b4 avdd pfet_06v0 ad=2.24p pd=8.56u as=2.24p ps=8.56u w=8u l=0.55u
X693 b4 bsb ain avdd pfet_06v0 ad=2.24p pd=8.56u as=2.24p ps=8.56u w=8u l=0.55u
X694 b6 sg6 vss vss nfet_06v0 ad=2.24p pd=8.56u as=4p ps=17u w=8u l=1.4u
X695 vss sg6 b6 vss nfet_06v0 ad=4p pd=17u as=2.24p ps=8.56u w=8u l=1.4u
X696 vss sg6 b6 vss nfet_06v0 ad=2.24p pd=8.56u as=2.24p ps=8.56u w=8u l=1.4u
X697 b6 sg6 vss vss nfet_06v0 ad=2.24p pd=8.56u as=2.24p ps=8.56u w=8u l=1.4u
X698 b3 sg3 vss vss nfet_06v0 ad=2p pd=9u as=2p ps=9u w=4u l=1.4u
X699 b8 sg8 vss vss nfet_06v0 ad=2.24p pd=8.56u as=4p ps=17u w=8u l=1.4u
X700 vss sg8 b8 vss nfet_06v0 ad=2.24p pd=8.56u as=2.24p ps=8.56u w=8u l=1.4u m=14
X708 vss sg8 b8 vss nfet_06v0 ad=4p pd=17u as=2.24p ps=8.56u w=8u l=1.4u
X715 vrefp sr3 b3 vss nfet_06v0 ad=0 pd=0 as=0 ps=0 w=4u l=1.4u
X716 vrefp sr6 b6 vss nfet_06v0 ad=0 pd=0 as=42.88p ps=0.17072m w=8u l=1.4u
X717 b6 sr6 vrefp vss nfet_06v0 ad=0 pd=0 as=0 ps=0 w=8u l=1.4u
X718 b6 sr6 vrefp vss nfet_06v0 ad=0 pd=0 as=0 ps=0 w=8u l=1.4u
X719 vrefp sr6 b6 vss nfet_06v0 ad=0 pd=0 as=0 ps=0 w=8u l=1.4u
X720 vrefp sr8 b8 vss nfet_06v0 ad=0 pd=0 as=0.1504n ps=0.5816m w=8u l=1.4u
X721 b8 sr8 vrefp vss nfet_06v0 ad=0 pd=0 as=0 ps=0 w=8u l=1.4u m=15
X736 ain bsb b3 avdd pfet_06v0 ad=2.24p pd=8.56u as=4p ps=17u w=8u l=0.55u
X737 b3 bsb ain avdd pfet_06v0 ad=4p pd=17u as=2.24p ps=8.56u w=8u l=0.55u
X738 b5 sg5 vss vss nfet_06v0 ad=2.24p pd=8.56u as=4p ps=17u w=8u l=1.4u
X739 vss sg5 b5 vss nfet_06v0 ad=4p pd=17u as=2.24p ps=8.56u w=8u l=1.4u
X740 ain bsb b2 avdd pfet_06v0 ad=0.56p pd=2.56u as=1p ps=5u w=2u l=0.55u
X741 b2 bsb ain avdd pfet_06v0 ad=1p pd=5u as=0.56p ps=2.56u w=2u l=0.55u
X742 ain bsb b2 avdd pfet_06v0 ad=0.56p pd=2.56u as=0.56p ps=2.56u w=2u l=0.55u
X743 b2 bsb ain avdd pfet_06v0 ad=0.56p pd=2.56u as=0.56p ps=2.56u w=2u l=0.55u
X744 vrefp sr5 b5 vss nfet_06v0 ad=0 pd=0 as=24.96p ps=0.10224m w=8u l=1.4u
X745 b5 sr5 vrefp vss nfet_06v0 ad=0 pd=0 as=0 ps=0 w=8u l=1.4u
X746 ain bs b5 vss nfet_06v0 ad=2.24p pd=8.56u as=4p ps=17u w=8u l=0.7u
X747 b5 bs ain vss nfet_06v0 ad=4p pd=17u as=2.24p ps=8.56u w=8u l=0.7u
X748 b5 bs ain vss nfet_06v0 ad=2.24p pd=8.56u as=2.24p ps=8.56u w=8u l=0.7u
X749 ain bs b5 vss nfet_06v0 ad=2.24p pd=8.56u as=2.24p ps=8.56u w=8u l=0.7u
X750 vrefp rb0 b0 avdd pfet_06v0 ad=0.5p pd=3u as=0.5p ps=3u w=1u l=1.2u
X751 ain bsb b7 avdd pfet_06v0 ad=2.24p pd=8.56u as=4p ps=17u w=8u l=0.55u
X752 b7 bsb ain avdd pfet_06v0 ad=2.24p pd=8.56u as=2.24p ps=8.56u w=8u l=0.55u m=30
X777 b7 bsb ain avdd pfet_06v0 ad=4p pd=17u as=2.24p ps=8.56u w=8u l=0.55u
X783 ain bsb b1 avdd pfet_06v0 ad=0.56p pd=2.56u as=1p ps=5u w=2u l=0.55u
X784 b1 bsb ain avdd pfet_06v0 ad=1p pd=5u as=0.56p ps=2.56u w=2u l=0.55u
X785 avdd nr5 sr5 avdd pfet_05v0 ad=1.14375p pd=4.91u as=0.59475p ps=2.48u w=1.83u l=0.5u
X786 sr5 nr5 vss vss nfet_05v0 ad=0.363p pd=1.87u as=0.5808p ps=3.52u w=1.32u l=0.6u
X787 vss nr5 sr5 vss nfet_05v0 ad=0.5808p pd=3.52u as=0.363p ps=1.87u w=1.32u l=0.6u
X788 sr5 nr5 avdd avdd pfet_05v0 ad=0.59475p pd=2.48u as=0.8052p ps=4.54u w=1.83u l=0.5u
X789 avdd hsg gn5 avdd pfet_05v0 ad=0.3796p pd=1.98u as=0.3796p ps=1.98u w=1.46u l=0.5u
X790 rv328_adcfe_p2_0/gf180mcu_fd_sc_mcu9t5v0__nand3_1_5/a_271_69# rb5 vss vss nfet_05v0 ad=0.2112p pd=1.64u as=0.5808p ps=3.52u w=1.32u l=0.6u
X791 rv328_adcfe_p2_0/gf180mcu_fd_sc_mcu9t5v0__nand3_1_5/a_455_69# hsg rv328_adcfe_p2_0/gf180mcu_fd_sc_mcu9t5v0__nand3_1_5/a_271_69# vss nfet_05v0 ad=0.2772p pd=1.74u as=0.2112p ps=1.64u w=1.32u l=0.6u
X792 gn5 db5 avdd avdd pfet_05v0 ad=0.6424p pd=3.8u as=0.3796p ps=1.98u w=1.46u l=0.5u
X793 gn5 db5 rv328_adcfe_p2_0/gf180mcu_fd_sc_mcu9t5v0__nand3_1_5/a_455_69# vss nfet_05v0 ad=0.5808p pd=3.52u as=0.2772p ps=1.74u w=1.32u l=0.6u
X794 gn5 rb5 avdd avdd pfet_05v0 ad=0.3796p pd=1.98u as=0.6424p ps=3.8u w=1.46u l=0.5u
X795 avdd hsg gn2 avdd pfet_05v0 ad=0 pd=0 as=1.4016p ps=7.76u w=1.46u l=0.5u
X796 rv328_adcfe_p2_0/gf180mcu_fd_sc_mcu9t5v0__nand3_1_6/a_271_69# rb2 vss vss nfet_05v0 ad=0.4224p pd=3.28u as=0 ps=0 w=1.32u l=0.6u
X797 rv328_adcfe_p2_0/gf180mcu_fd_sc_mcu9t5v0__nand3_1_6/a_455_69# hsg rv328_adcfe_p2_0/gf180mcu_fd_sc_mcu9t5v0__nand3_1_6/a_271_69# vss nfet_05v0 ad=0.5544p pd=3.48u as=0 ps=0 w=1.32u l=0.6u
X798 gn2 db2 avdd avdd pfet_05v0 ad=0 pd=0 as=0 ps=0 w=1.46u l=0.5u
X799 gn2 db2 rv328_adcfe_p2_0/gf180mcu_fd_sc_mcu9t5v0__nand3_1_6/a_455_69# vss nfet_05v0 ad=0.5808p pd=3.52u as=0 ps=0 w=1.32u l=0.6u
X800 gn2 rb2 avdd avdd pfet_05v0 ad=0 pd=0 as=0 ps=0 w=1.46u l=0.5u
X801 avdd ts tsb avdd pfet_05v0 ad=0 pd=0 as=1.1895p ps=4.96u w=1.83u l=0.5u
X802 tsb ts vss vss nfet_05v0 ad=0.726p pd=3.74u as=0 ps=0 w=1.32u l=0.6u
X803 vss ts tsb vss nfet_05v0 ad=0 pd=0 as=0 ps=0 w=1.32u l=0.6u
X804 tsb ts avdd avdd pfet_05v0 ad=0 pd=0 as=0 ps=0 w=1.83u l=0.5u
X805 avdd gn5 sg5 avdd pfet_05v0 ad=0 pd=0 as=1.1895p ps=4.96u w=1.83u l=0.5u
X806 sg5 gn5 vss vss nfet_05v0 ad=0.726p pd=3.74u as=0 ps=0 w=1.32u l=0.6u
X807 vss gn5 sg5 vss nfet_05v0 ad=0 pd=0 as=0 ps=0 w=1.32u l=0.6u
X808 sg5 gn5 avdd avdd pfet_05v0 ad=0 pd=0 as=0 ps=0 w=1.83u l=0.5u
X809 avdd hs nr2 avdd pfet_05v0 ad=0 pd=0 as=1.4016p ps=7.76u w=1.46u l=0.5u
X810 rv328_adcfe_p2_0/gf180mcu_fd_sc_mcu9t5v0__nand3_1_7/a_271_69# gb2 vss vss nfet_05v0 ad=0.4224p pd=3.28u as=0 ps=0 w=1.32u l=0.6u
X811 rv328_adcfe_p2_0/gf180mcu_fd_sc_mcu9t5v0__nand3_1_7/a_455_69# hs rv328_adcfe_p2_0/gf180mcu_fd_sc_mcu9t5v0__nand3_1_7/a_271_69# vss nfet_05v0 ad=0.5544p pd=3.48u as=0 ps=0 w=1.32u l=0.6u
X812 nr2 d2 avdd avdd pfet_05v0 ad=0 pd=0 as=0 ps=0 w=1.46u l=0.5u
X813 nr2 d2 rv328_adcfe_p2_0/gf180mcu_fd_sc_mcu9t5v0__nand3_1_7/a_455_69# vss nfet_05v0 ad=0.5808p pd=3.52u as=0 ps=0 w=1.32u l=0.6u
X814 nr2 gb2 avdd avdd pfet_05v0 ad=0 pd=0 as=0 ps=0 w=1.46u l=0.5u
X815 avdd sr5 rb5 avdd pfet_05v0 ad=0 pd=0 as=1.1895p ps=4.96u w=1.83u l=0.5u
X816 rb5 sr5 vss vss nfet_05v0 ad=0.726p pd=3.74u as=0 ps=0 w=1.32u l=0.6u
X817 vss sr5 rb5 vss nfet_05v0 ad=0 pd=0 as=0 ps=0 w=1.32u l=0.6u
X818 rb5 sr5 avdd avdd pfet_05v0 ad=0 pd=0 as=0 ps=0 w=1.83u l=0.5u
X819 avdd hsg gn1 avdd pfet_05v0 ad=0 pd=0 as=1.4016p ps=7.76u w=1.46u l=0.5u
X820 rv328_adcfe_p2_0/gf180mcu_fd_sc_mcu9t5v0__nand3_1_8/a_271_69# rb1 vss vss nfet_05v0 ad=0.4224p pd=3.28u as=0 ps=0 w=1.32u l=0.6u
X821 rv328_adcfe_p2_0/gf180mcu_fd_sc_mcu9t5v0__nand3_1_8/a_455_69# hsg rv328_adcfe_p2_0/gf180mcu_fd_sc_mcu9t5v0__nand3_1_8/a_271_69# vss nfet_05v0 ad=0.5544p pd=3.48u as=0 ps=0 w=1.32u l=0.6u
X822 gn1 db1 avdd avdd pfet_05v0 ad=0 pd=0 as=0 ps=0 w=1.46u l=0.5u
X823 gn1 db1 rv328_adcfe_p2_0/gf180mcu_fd_sc_mcu9t5v0__nand3_1_8/a_455_69# vss nfet_05v0 ad=0.5808p pd=3.52u as=0 ps=0 w=1.32u l=0.6u
X824 gn1 rb1 avdd avdd pfet_05v0 ad=0 pd=0 as=0 ps=0 w=1.46u l=0.5u
X825 avdd hsg gn6 avdd pfet_05v0 ad=0 pd=0 as=1.4016p ps=7.76u w=1.46u l=0.5u
X826 rv328_adcfe_p2_0/gf180mcu_fd_sc_mcu9t5v0__nand3_1_20/a_271_69# rb6 vss vss nfet_05v0 ad=0.4224p pd=3.28u as=0 ps=0 w=1.32u l=0.6u
X827 rv328_adcfe_p2_0/gf180mcu_fd_sc_mcu9t5v0__nand3_1_20/a_455_69# hsg rv328_adcfe_p2_0/gf180mcu_fd_sc_mcu9t5v0__nand3_1_20/a_271_69# vss nfet_05v0 ad=0.5544p pd=3.48u as=0 ps=0 w=1.32u l=0.6u
X828 gn6 db6 avdd avdd pfet_05v0 ad=0 pd=0 as=0 ps=0 w=1.46u l=0.5u
X829 gn6 db6 rv328_adcfe_p2_0/gf180mcu_fd_sc_mcu9t5v0__nand3_1_20/a_455_69# vss nfet_05v0 ad=0.5808p pd=3.52u as=0 ps=0 w=1.32u l=0.6u
X830 gn6 rb6 avdd avdd pfet_05v0 ad=0 pd=0 as=0 ps=0 w=1.46u l=0.5u
X831 avdd hs nr1 avdd pfet_05v0 ad=0 pd=0 as=1.4016p ps=7.76u w=1.46u l=0.5u
X832 rv328_adcfe_p2_0/gf180mcu_fd_sc_mcu9t5v0__nand3_1_9/a_271_69# gb1 vss vss nfet_05v0 ad=0.4224p pd=3.28u as=0 ps=0 w=1.32u l=0.6u
X833 rv328_adcfe_p2_0/gf180mcu_fd_sc_mcu9t5v0__nand3_1_9/a_455_69# hs rv328_adcfe_p2_0/gf180mcu_fd_sc_mcu9t5v0__nand3_1_9/a_271_69# vss nfet_05v0 ad=0.5544p pd=3.48u as=0 ps=0 w=1.32u l=0.6u
X834 nr1 d1 avdd avdd pfet_05v0 ad=0 pd=0 as=0 ps=0 w=1.46u l=0.5u
X835 nr1 d1 rv328_adcfe_p2_0/gf180mcu_fd_sc_mcu9t5v0__nand3_1_9/a_455_69# vss nfet_05v0 ad=0.5808p pd=3.52u as=0 ps=0 w=1.32u l=0.6u
X836 nr1 gb1 avdd avdd pfet_05v0 ad=0 pd=0 as=0 ps=0 w=1.46u l=0.5u
X837 avdd hsg gn0 avdd pfet_05v0 ad=0 pd=0 as=1.4016p ps=7.76u w=1.46u l=0.5u
X838 rv328_adcfe_p2_0/gf180mcu_fd_sc_mcu9t5v0__nand3_1_10/a_271_69# rb0 vss vss nfet_05v0 ad=0.4224p pd=3.28u as=0 ps=0 w=1.32u l=0.6u
X839 rv328_adcfe_p2_0/gf180mcu_fd_sc_mcu9t5v0__nand3_1_10/a_455_69# hsg rv328_adcfe_p2_0/gf180mcu_fd_sc_mcu9t5v0__nand3_1_10/a_271_69# vss nfet_05v0 ad=0.5544p pd=3.48u as=0 ps=0 w=1.32u l=0.6u
X840 gn0 db0 avdd avdd pfet_05v0 ad=0 pd=0 as=0 ps=0 w=1.46u l=0.5u
X841 gn0 db0 rv328_adcfe_p2_0/gf180mcu_fd_sc_mcu9t5v0__nand3_1_10/a_455_69# vss nfet_05v0 ad=0.5808p pd=3.52u as=0 ps=0 w=1.32u l=0.6u
X842 gn0 rb0 avdd avdd pfet_05v0 ad=0 pd=0 as=0 ps=0 w=1.46u l=0.5u
X843 avdd hs nr0 avdd pfet_05v0 ad=0 pd=0 as=1.4016p ps=7.76u w=1.46u l=0.5u
X844 rv328_adcfe_p2_0/gf180mcu_fd_sc_mcu9t5v0__nand3_1_11/a_271_69# gb0 vss vss nfet_05v0 ad=0.4224p pd=3.28u as=0 ps=0 w=1.32u l=0.6u
X845 rv328_adcfe_p2_0/gf180mcu_fd_sc_mcu9t5v0__nand3_1_11/a_455_69# hs rv328_adcfe_p2_0/gf180mcu_fd_sc_mcu9t5v0__nand3_1_11/a_271_69# vss nfet_05v0 ad=0.5544p pd=3.48u as=0 ps=0 w=1.32u l=0.6u
X846 nr0 d0 avdd avdd pfet_05v0 ad=0 pd=0 as=0 ps=0 w=1.46u l=0.5u
X847 nr0 d0 rv328_adcfe_p2_0/gf180mcu_fd_sc_mcu9t5v0__nand3_1_11/a_455_69# vss nfet_05v0 ad=0.5808p pd=3.52u as=0 ps=0 w=1.32u l=0.6u
X848 nr0 gb0 avdd avdd pfet_05v0 ad=0 pd=0 as=0 ps=0 w=1.46u l=0.5u
X849 hsn bsb avdd avdd pfet_05v0 ad=0.4277p pd=2.165u as=0.7238p ps=4.17u w=1.645u l=0.5u
X850 avdd ab hsn avdd pfet_05v0 ad=0.7238p pd=4.17u as=0.4277p ps=2.165u w=1.645u l=0.5u
X851 hsn ab rv328_adcfe_p2_0/gf180mcu_fd_sc_mcu9t5v0__nand2_1_0/a_245_69# vss nfet_05v0 ad=0.5808p pd=3.52u as=0.2112p ps=1.64u w=1.32u l=0.6u
X852 rv328_adcfe_p2_0/gf180mcu_fd_sc_mcu9t5v0__nand2_1_0/a_245_69# bsb vss vss nfet_05v0 ad=0.2112p pd=1.64u as=0.5808p ps=3.52u w=1.32u l=0.6u
X853 avdd hsb bsn avdd pfet_05v0 ad=0 pd=0 as=1.4016p ps=7.76u w=1.46u l=0.5u
X854 rv328_adcfe_p2_0/gf180mcu_fd_sc_mcu9t5v0__nand3_1_12/a_271_69# hsgs vss vss nfet_05v0 ad=0.4224p pd=3.28u as=0 ps=0 w=1.32u l=0.6u
X855 rv328_adcfe_p2_0/gf180mcu_fd_sc_mcu9t5v0__nand3_1_12/a_455_69# hsb rv328_adcfe_p2_0/gf180mcu_fd_sc_mcu9t5v0__nand3_1_12/a_271_69# vss nfet_05v0 ad=0.5544p pd=3.48u as=0 ps=0 w=1.32u l=0.6u
X856 bsn a avdd avdd pfet_05v0 ad=0 pd=0 as=0 ps=0 w=1.46u l=0.5u
X857 bsn a rv328_adcfe_p2_0/gf180mcu_fd_sc_mcu9t5v0__nand3_1_12/a_455_69# vss nfet_05v0 ad=0.5808p pd=3.52u as=0 ps=0 w=1.32u l=0.6u
X858 bsn hsgs avdd avdd pfet_05v0 ad=0 pd=0 as=0 ps=0 w=1.46u l=0.5u
X859 avdd hs nr5 avdd pfet_05v0 ad=0 pd=0 as=1.4016p ps=7.76u w=1.46u l=0.5u
X860 rv328_adcfe_p2_0/gf180mcu_fd_sc_mcu9t5v0__nand3_1_13/a_271_69# gb5 vss vss nfet_05v0 ad=0.4224p pd=3.28u as=0 ps=0 w=1.32u l=0.6u
X861 rv328_adcfe_p2_0/gf180mcu_fd_sc_mcu9t5v0__nand3_1_13/a_455_69# hs rv328_adcfe_p2_0/gf180mcu_fd_sc_mcu9t5v0__nand3_1_13/a_271_69# vss nfet_05v0 ad=0.5544p pd=3.48u as=0 ps=0 w=1.32u l=0.6u
X862 nr5 d5 avdd avdd pfet_05v0 ad=0 pd=0 as=0 ps=0 w=1.46u l=0.5u
X863 nr5 d5 rv328_adcfe_p2_0/gf180mcu_fd_sc_mcu9t5v0__nand3_1_13/a_455_69# vss nfet_05v0 ad=0.5808p pd=3.52u as=0 ps=0 w=1.32u l=0.6u
X864 nr5 gb5 avdd avdd pfet_05v0 ad=0 pd=0 as=0 ps=0 w=1.46u l=0.5u
X865 avdd hsg gn4 avdd pfet_05v0 ad=0 pd=0 as=1.4016p ps=7.76u w=1.46u l=0.5u
X866 rv328_adcfe_p2_0/gf180mcu_fd_sc_mcu9t5v0__nand3_1_14/a_271_69# rb4 vss vss nfet_05v0 ad=0.4224p pd=3.28u as=0 ps=0 w=1.32u l=0.6u
X867 rv328_adcfe_p2_0/gf180mcu_fd_sc_mcu9t5v0__nand3_1_14/a_455_69# hsg rv328_adcfe_p2_0/gf180mcu_fd_sc_mcu9t5v0__nand3_1_14/a_271_69# vss nfet_05v0 ad=0.5544p pd=3.48u as=0 ps=0 w=1.32u l=0.6u
X868 gn4 db4 avdd avdd pfet_05v0 ad=0 pd=0 as=0 ps=0 w=1.46u l=0.5u
X869 gn4 db4 rv328_adcfe_p2_0/gf180mcu_fd_sc_mcu9t5v0__nand3_1_14/a_455_69# vss nfet_05v0 ad=0.5808p pd=3.52u as=0 ps=0 w=1.32u l=0.6u
X870 gn4 rb4 avdd avdd pfet_05v0 ad=0 pd=0 as=0 ps=0 w=1.46u l=0.5u
X871 avdd hs nr4 avdd pfet_05v0 ad=0 pd=0 as=1.4016p ps=7.76u w=1.46u l=0.5u
X872 rv328_adcfe_p2_0/gf180mcu_fd_sc_mcu9t5v0__nand3_1_15/a_271_69# gb4 vss vss nfet_05v0 ad=0.4224p pd=3.28u as=0 ps=0 w=1.32u l=0.6u
X873 rv328_adcfe_p2_0/gf180mcu_fd_sc_mcu9t5v0__nand3_1_15/a_455_69# hs rv328_adcfe_p2_0/gf180mcu_fd_sc_mcu9t5v0__nand3_1_15/a_271_69# vss nfet_05v0 ad=0.5544p pd=3.48u as=0 ps=0 w=1.32u l=0.6u
X874 nr4 d4 avdd avdd pfet_05v0 ad=0 pd=0 as=0 ps=0 w=1.46u l=0.5u
X875 nr4 d4 rv328_adcfe_p2_0/gf180mcu_fd_sc_mcu9t5v0__nand3_1_15/a_455_69# vss nfet_05v0 ad=0.5808p pd=3.52u as=0 ps=0 w=1.32u l=0.6u
X876 nr4 gb4 avdd avdd pfet_05v0 ad=0 pd=0 as=0 ps=0 w=1.46u l=0.5u
X877 avdd hsg gn3 avdd pfet_05v0 ad=0 pd=0 as=1.4016p ps=7.76u w=1.46u l=0.5u
X878 rv328_adcfe_p2_0/gf180mcu_fd_sc_mcu9t5v0__nand3_1_16/a_271_69# rb3 vss vss nfet_05v0 ad=0.4224p pd=3.28u as=0 ps=0 w=1.32u l=0.6u
X879 rv328_adcfe_p2_0/gf180mcu_fd_sc_mcu9t5v0__nand3_1_16/a_455_69# hsg rv328_adcfe_p2_0/gf180mcu_fd_sc_mcu9t5v0__nand3_1_16/a_271_69# vss nfet_05v0 ad=0.5544p pd=3.48u as=0 ps=0 w=1.32u l=0.6u
X880 gn3 db3 avdd avdd pfet_05v0 ad=0 pd=0 as=0 ps=0 w=1.46u l=0.5u
X881 gn3 db3 rv328_adcfe_p2_0/gf180mcu_fd_sc_mcu9t5v0__nand3_1_16/a_455_69# vss nfet_05v0 ad=0.5808p pd=3.52u as=0 ps=0 w=1.32u l=0.6u
X882 gn3 rb3 avdd avdd pfet_05v0 ad=0 pd=0 as=0 ps=0 w=1.46u l=0.5u
X883 avdd hs nr3 avdd pfet_05v0 ad=0 pd=0 as=1.4016p ps=7.76u w=1.46u l=0.5u
X884 rv328_adcfe_p2_0/gf180mcu_fd_sc_mcu9t5v0__nand3_1_17/a_271_69# gb3 vss vss nfet_05v0 ad=0.4224p pd=3.28u as=0 ps=0 w=1.32u l=0.6u
X885 rv328_adcfe_p2_0/gf180mcu_fd_sc_mcu9t5v0__nand3_1_17/a_455_69# hs rv328_adcfe_p2_0/gf180mcu_fd_sc_mcu9t5v0__nand3_1_17/a_271_69# vss nfet_05v0 ad=0.5544p pd=3.48u as=0 ps=0 w=1.32u l=0.6u
X886 nr3 d3 avdd avdd pfet_05v0 ad=0 pd=0 as=0 ps=0 w=1.46u l=0.5u
X887 nr3 d3 rv328_adcfe_p2_0/gf180mcu_fd_sc_mcu9t5v0__nand3_1_17/a_455_69# vss nfet_05v0 ad=0.5808p pd=3.52u as=0 ps=0 w=1.32u l=0.6u
X888 nr3 gb3 avdd avdd pfet_05v0 ad=0 pd=0 as=0 ps=0 w=1.46u l=0.5u
X889 avdd hs nr8 avdd pfet_05v0 ad=0 pd=0 as=1.4016p ps=7.76u w=1.46u l=0.5u
X890 rv328_adcfe_p2_0/gf180mcu_fd_sc_mcu9t5v0__nand3_1_18/a_271_69# gb8 vss vss nfet_05v0 ad=0.4224p pd=3.28u as=0 ps=0 w=1.32u l=0.6u
X891 rv328_adcfe_p2_0/gf180mcu_fd_sc_mcu9t5v0__nand3_1_18/a_455_69# hs rv328_adcfe_p2_0/gf180mcu_fd_sc_mcu9t5v0__nand3_1_18/a_271_69# vss nfet_05v0 ad=0.5544p pd=3.48u as=0 ps=0 w=1.32u l=0.6u
X892 nr8 d8 avdd avdd pfet_05v0 ad=0 pd=0 as=0 ps=0 w=1.46u l=0.5u
X893 nr8 d8 rv328_adcfe_p2_0/gf180mcu_fd_sc_mcu9t5v0__nand3_1_18/a_455_69# vss nfet_05v0 ad=0.5808p pd=3.52u as=0 ps=0 w=1.32u l=0.6u
X894 nr8 gb8 avdd avdd pfet_05v0 ad=0 pd=0 as=0 ps=0 w=1.46u l=0.5u
X895 avdd hsg gn7 avdd pfet_05v0 ad=0 pd=0 as=1.4016p ps=7.76u w=1.46u l=0.5u
X896 rv328_adcfe_p2_0/gf180mcu_fd_sc_mcu9t5v0__nand3_1_19/a_271_69# rb7 vss vss nfet_05v0 ad=0.4224p pd=3.28u as=0 ps=0 w=1.32u l=0.6u
X897 rv328_adcfe_p2_0/gf180mcu_fd_sc_mcu9t5v0__nand3_1_19/a_455_69# hsg rv328_adcfe_p2_0/gf180mcu_fd_sc_mcu9t5v0__nand3_1_19/a_271_69# vss nfet_05v0 ad=0.5544p pd=3.48u as=0 ps=0 w=1.32u l=0.6u
X898 gn7 db7 avdd avdd pfet_05v0 ad=0 pd=0 as=0 ps=0 w=1.46u l=0.5u
X899 gn7 db7 rv328_adcfe_p2_0/gf180mcu_fd_sc_mcu9t5v0__nand3_1_19/a_455_69# vss nfet_05v0 ad=0.5808p pd=3.52u as=0 ps=0 w=1.32u l=0.6u
X900 gn7 rb7 avdd avdd pfet_05v0 ad=0 pd=0 as=0 ps=0 w=1.46u l=0.5u
X901 gb9 sg9 avdd avdd pfet_05v0 ad=0.8052p pd=4.54u as=0.8052p ps=4.54u w=1.83u l=0.5u
X902 gb9 sg9 vss vss nfet_05v0 ad=0.5808p pd=3.52u as=0.5808p ps=3.52u w=1.32u l=0.6u
X903 db9 d9 avdd avdd pfet_05v0 ad=0.8052p pd=4.54u as=0 ps=0 w=1.83u l=0.5u
X904 db9 d9 vss vss nfet_05v0 ad=0.5808p pd=3.52u as=0 ps=0 w=1.32u l=0.6u
X905 gb8 sg8 avdd avdd pfet_05v0 ad=0.8052p pd=4.54u as=0 ps=0 w=1.83u l=0.5u
X906 gb8 sg8 vss vss nfet_05v0 ad=0.5808p pd=3.52u as=0 ps=0 w=1.32u l=0.6u
X907 db1 d1 avdd avdd pfet_05v0 ad=0.8052p pd=4.54u as=0 ps=0 w=1.83u l=0.5u
X908 db1 d1 vss vss nfet_05v0 ad=0.5808p pd=3.52u as=0 ps=0 w=1.32u l=0.6u
X909 sg3 gn3 avdd avdd pfet_05v0 ad=0.8052p pd=4.54u as=0 ps=0 w=1.83u l=0.5u
X910 sg3 gn3 vss vss nfet_05v0 ad=0.5808p pd=3.52u as=0 ps=0 w=1.32u l=0.6u
X911 hsb hs avdd avdd pfet_05v0 ad=0.8052p pd=4.54u as=0 ps=0 w=1.83u l=0.5u
X912 hsb hs vss vss nfet_05v0 ad=0.5808p pd=3.52u as=0 ps=0 w=1.32u l=0.6u
X913 hsgs hsg avdd avdd pfet_05v0 ad=0.8052p pd=4.54u as=0 ps=0 w=1.83u l=0.5u
X914 hsgs hsg vss vss nfet_05v0 ad=0.5808p pd=3.52u as=0 ps=0 w=1.32u l=0.6u
X915 sg0 gn0 avdd avdd pfet_05v0 ad=0.8052p pd=4.54u as=0 ps=0 w=1.83u l=0.5u
X916 sg0 gn0 vss vss nfet_05v0 ad=0.5808p pd=3.52u as=0 ps=0 w=1.32u l=0.6u
X917 azn az avdd avdd pfet_05v0 ad=0.8052p pd=4.54u as=0 ps=0 w=1.83u l=0.5u
X918 azn az vss vss nfet_05v0 ad=0.5808p pd=3.52u as=0 ps=0 w=1.32u l=0.6u
X919 rb1 sr1 avdd avdd pfet_05v0 ad=0.8052p pd=4.54u as=0 ps=0 w=1.83u l=0.5u
X920 rb1 sr1 vss vss nfet_05v0 ad=0.5808p pd=3.52u as=0 ps=0 w=1.32u l=0.6u
X921 rb8 sr8 avdd avdd pfet_05v0 ad=0.5673p pd=2.45u as=0.5673p ps=2.45u w=1.83u l=0.5u m=14
X922 avdd sr8 rb8 avdd pfet_05v0 ad=0.8052p pd=4.54u as=0.5673p ps=2.45u w=1.83u l=0.5u
X923 vss sr8 rb8 vss nfet_05v0 ad=0.3432p pd=1.84u as=0.3432p ps=1.84u w=1.32u l=0.6u m=14
X936 rb8 sr8 vss vss nfet_05v0 ad=0.3432p pd=1.84u as=0.5808p ps=3.52u w=1.32u l=0.6u
X939 vss sr8 rb8 vss nfet_05v0 ad=0.5808p pd=3.52u as=0.3432p ps=1.84u w=1.32u l=0.6u
X949 rb8 sr8 avdd avdd pfet_05v0 ad=0.5673p pd=2.45u as=0.8052p ps=4.54u w=1.83u l=0.5u
X953 rb3 sr3 avdd avdd pfet_05v0 ad=0.8052p pd=4.54u as=0 ps=0 w=1.83u l=0.5u
X954 rb3 sr3 vss vss nfet_05v0 ad=0.5808p pd=3.52u as=0 ps=0 w=1.32u l=0.6u
X955 sg7 gn7 avdd avdd pfet_05v0 ad=0.5673p pd=2.45u as=0.5673p ps=2.45u w=1.83u l=0.5u
X956 vss gn7 sg7 vss nfet_05v0 ad=0.3432p pd=1.84u as=0.3432p ps=1.84u w=1.32u l=0.6u
X957 avdd gn7 sg7 avdd pfet_05v0 ad=0.5673p pd=2.45u as=0.5673p ps=2.45u w=1.83u l=0.5u
X958 vss gn7 sg7 vss nfet_05v0 ad=0.3432p pd=1.84u as=0.3432p ps=1.84u w=1.32u l=0.6u
X959 sg7 gn7 vss vss nfet_05v0 ad=0.3432p pd=1.84u as=0.3432p ps=1.84u w=1.32u l=0.6u
X960 avdd gn7 sg7 avdd pfet_05v0 ad=0.8052p pd=4.54u as=0.5673p ps=2.45u w=1.83u l=0.5u
X961 sg7 gn7 vss vss nfet_05v0 ad=0.3432p pd=1.84u as=0.3432p ps=1.84u w=1.32u l=0.6u
X962 avdd gn7 sg7 avdd pfet_05v0 ad=0.5673p pd=2.45u as=0.5673p ps=2.45u w=1.83u l=0.5u
X963 sg7 gn7 vss vss nfet_05v0 ad=0.3432p pd=1.84u as=0.5808p ps=3.52u w=1.32u l=0.6u
X964 sg7 gn7 avdd avdd pfet_05v0 ad=0.5673p pd=2.45u as=0.5673p ps=2.45u w=1.83u l=0.5u
X965 avdd gn7 sg7 avdd pfet_05v0 ad=0.5673p pd=2.45u as=0.5673p ps=2.45u w=1.83u l=0.5u
X966 sg7 gn7 vss vss nfet_05v0 ad=0.3432p pd=1.84u as=0.3432p ps=1.84u w=1.32u l=0.6u
X967 sg7 gn7 avdd avdd pfet_05v0 ad=0.5673p pd=2.45u as=0.5673p ps=2.45u w=1.83u l=0.5u
X968 sg7 gn7 avdd avdd pfet_05v0 ad=0.5673p pd=2.45u as=0.8052p ps=4.54u w=1.83u l=0.5u
X969 vss gn7 sg7 vss nfet_05v0 ad=0.5808p pd=3.52u as=0.3432p ps=1.84u w=1.32u l=0.6u
X970 vss gn7 sg7 vss nfet_05v0 ad=0.3432p pd=1.84u as=0.3432p ps=1.84u w=1.32u l=0.6u
X971 ts0 sample avdd avdd pfet_05v0 ad=0.8052p pd=4.54u as=0 ps=0 w=1.83u l=0.5u
X972 ts0 sample vss vss nfet_05v0 ad=0.5808p pd=3.52u as=0 ps=0 w=1.32u l=0.6u
X973 db3 d3 avdd avdd pfet_05v0 ad=0.8052p pd=4.54u as=0 ps=0 w=1.83u l=0.5u
X974 db3 d3 vss vss nfet_05v0 ad=0.5808p pd=3.52u as=0 ps=0 w=1.32u l=0.6u
X975 sg4 gn4 avdd avdd pfet_05v0 ad=0.8052p pd=4.54u as=0 ps=0 w=1.83u l=0.5u
X976 sg4 gn4 vss vss nfet_05v0 ad=0.5808p pd=3.52u as=0 ps=0 w=1.32u l=0.6u
X977 rb7 sr7 avdd avdd pfet_05v0 ad=4.5384p pd=19.6u as=0 ps=0 w=1.83u l=0.5u
X978 vss sr7 rb7 vss nfet_05v0 ad=0 pd=0 as=2.7456p ps=14.72u w=1.32u l=0.6u
X979 avdd sr7 rb7 avdd pfet_05v0 ad=0 pd=0 as=0 ps=0 w=1.83u l=0.5u
X980 vss sr7 rb7 vss nfet_05v0 ad=0 pd=0 as=0 ps=0 w=1.32u l=0.6u
X981 rb7 sr7 vss vss nfet_05v0 ad=0 pd=0 as=0 ps=0 w=1.32u l=0.6u
X982 avdd sr7 rb7 avdd pfet_05v0 ad=0 pd=0 as=0 ps=0 w=1.83u l=0.5u
X983 rb7 sr7 vss vss nfet_05v0 ad=0 pd=0 as=0 ps=0 w=1.32u l=0.6u
X984 avdd sr7 rb7 avdd pfet_05v0 ad=0 pd=0 as=0 ps=0 w=1.83u l=0.5u
X985 rb7 sr7 vss vss nfet_05v0 ad=0 pd=0 as=0 ps=0 w=1.32u l=0.6u
X986 rb7 sr7 avdd avdd pfet_05v0 ad=0 pd=0 as=0 ps=0 w=1.83u l=0.5u
X987 avdd sr7 rb7 avdd pfet_05v0 ad=0 pd=0 as=0 ps=0 w=1.83u l=0.5u
X988 rb7 sr7 vss vss nfet_05v0 ad=0 pd=0 as=0 ps=0 w=1.32u l=0.6u
X989 rb7 sr7 avdd avdd pfet_05v0 ad=0 pd=0 as=0 ps=0 w=1.83u l=0.5u
X990 rb7 sr7 avdd avdd pfet_05v0 ad=0 pd=0 as=0 ps=0 w=1.83u l=0.5u
X991 vss sr7 rb7 vss nfet_05v0 ad=0 pd=0 as=0 ps=0 w=1.32u l=0.6u
X992 vss sr7 rb7 vss nfet_05v0 ad=0 pd=0 as=0 ps=0 w=1.32u l=0.6u
X993 sr3 nr3 avdd avdd pfet_05v0 ad=0.8052p pd=4.54u as=0 ps=0 w=1.83u l=0.5u
X994 sr3 nr3 vss vss nfet_05v0 ad=0.5808p pd=3.52u as=0 ps=0 w=1.32u l=0.6u
X995 db6 d6 avdd avdd pfet_05v0 ad=0.8052p pd=4.54u as=0 ps=0 w=1.83u l=0.5u
X996 db6 d6 vss vss nfet_05v0 ad=0.5808p pd=3.52u as=0 ps=0 w=1.32u l=0.6u
X997 sg2 gn2 avdd avdd pfet_05v0 ad=0.8052p pd=4.54u as=0 ps=0 w=1.83u l=0.5u
X998 sg2 gn2 vss vss nfet_05v0 ad=0.5808p pd=3.52u as=0 ps=0 w=1.32u l=0.6u
X999 rb4 sr4 avdd avdd pfet_05v0 ad=0.8052p pd=4.54u as=0 ps=0 w=1.83u l=0.5u
X1000 rb4 sr4 vss vss nfet_05v0 ad=0.5808p pd=3.52u as=0 ps=0 w=1.32u l=0.6u
X1001 sg9 gn9 avdd avdd pfet_05v0 ad=18.1536p pd=78.4u as=0 ps=0 w=1.83u l=0.5u
X1002 avdd gn9 sg9 avdd pfet_05v0 ad=0 pd=0 as=0 ps=0 w=1.83u l=0.5u m=31
X1003 vss gn9 sg9 vss nfet_05v0 ad=0 pd=0 as=10.9824p ps=58.88u w=1.32u l=0.6u
X1005 vss gn9 sg9 vss nfet_05v0 ad=0 pd=0 as=0 ps=0 w=1.32u l=0.6u m=31
X1033 rb0 sr0 avdd avdd pfet_05v0 ad=0.8052p pd=4.54u as=0 ps=0 w=1.83u l=0.5u
X1034 rb0 sr0 vss vss nfet_05v0 ad=0.5808p pd=3.52u as=0 ps=0 w=1.32u l=0.6u
X1035 hsg q3 avdd avdd pfet_05v0 ad=4.5384p pd=19.6u as=0 ps=0 w=1.83u l=0.5u
X1036 vss q3 hsg vss nfet_05v0 ad=0 pd=0 as=2.7456p ps=14.72u w=1.32u l=0.6u
X1037 avdd q3 hsg avdd pfet_05v0 ad=0 pd=0 as=0 ps=0 w=1.83u l=0.5u
X1038 vss q3 hsg vss nfet_05v0 ad=0 pd=0 as=0 ps=0 w=1.32u l=0.6u
X1039 hsg q3 vss vss nfet_05v0 ad=0 pd=0 as=0 ps=0 w=1.32u l=0.6u
X1040 avdd q3 hsg avdd pfet_05v0 ad=0 pd=0 as=0 ps=0 w=1.83u l=0.5u
X1041 hsg q3 vss vss nfet_05v0 ad=0 pd=0 as=0 ps=0 w=1.32u l=0.6u
X1042 avdd q3 hsg avdd pfet_05v0 ad=0 pd=0 as=0 ps=0 w=1.83u l=0.5u
X1043 hsg q3 vss vss nfet_05v0 ad=0 pd=0 as=0 ps=0 w=1.32u l=0.6u
X1044 hsg q3 avdd avdd pfet_05v0 ad=0 pd=0 as=0 ps=0 w=1.83u l=0.5u
X1045 avdd q3 hsg avdd pfet_05v0 ad=0 pd=0 as=0 ps=0 w=1.83u l=0.5u
X1046 hsg q3 vss vss nfet_05v0 ad=0 pd=0 as=0 ps=0 w=1.32u l=0.6u
X1047 hsg q3 avdd avdd pfet_05v0 ad=0 pd=0 as=0 ps=0 w=1.83u l=0.5u
X1048 hsg q3 avdd avdd pfet_05v0 ad=0 pd=0 as=0 ps=0 w=1.83u l=0.5u
X1049 vss q3 hsg vss nfet_05v0 ad=0 pd=0 as=0 ps=0 w=1.32u l=0.6u
X1050 vss q3 hsg vss nfet_05v0 ad=0 pd=0 as=0 ps=0 w=1.32u l=0.6u
X1051 gb4 sg4 avdd avdd pfet_05v0 ad=0.8052p pd=4.54u as=0 ps=0 w=1.83u l=0.5u
X1052 gb4 sg4 vss vss nfet_05v0 ad=0.5808p pd=3.52u as=0 ps=0 w=1.32u l=0.6u
X1053 sr0 nr0 avdd avdd pfet_05v0 ad=0.8052p pd=4.54u as=0 ps=0 w=1.83u l=0.5u
X1054 sr0 nr0 vss vss nfet_05v0 ad=0.5808p pd=3.52u as=0 ps=0 w=1.32u l=0.6u
X1055 sr4 nr4 avdd avdd pfet_05v0 ad=0.8052p pd=4.54u as=0 ps=0 w=1.83u l=0.5u
X1056 sr4 nr4 vss vss nfet_05v0 ad=0.5808p pd=3.52u as=0 ps=0 w=1.32u l=0.6u
X1057 hs hsn avdd avdd pfet_05v0 ad=4.5384p pd=19.6u as=0 ps=0 w=1.83u l=0.5u
X1058 vss hsn hs vss nfet_05v0 ad=0 pd=0 as=2.7456p ps=14.72u w=1.32u l=0.6u
X1059 avdd hsn hs avdd pfet_05v0 ad=0 pd=0 as=0 ps=0 w=1.83u l=0.5u
X1060 vss hsn hs vss nfet_05v0 ad=0 pd=0 as=0 ps=0 w=1.32u l=0.6u
X1061 hs hsn vss vss nfet_05v0 ad=0 pd=0 as=0 ps=0 w=1.32u l=0.6u
X1062 avdd hsn hs avdd pfet_05v0 ad=0 pd=0 as=0 ps=0 w=1.83u l=0.5u
X1063 hs hsn vss vss nfet_05v0 ad=0 pd=0 as=0 ps=0 w=1.32u l=0.6u
X1064 avdd hsn hs avdd pfet_05v0 ad=0 pd=0 as=0 ps=0 w=1.83u l=0.5u
X1065 hs hsn vss vss nfet_05v0 ad=0 pd=0 as=0 ps=0 w=1.32u l=0.6u
X1066 hs hsn avdd avdd pfet_05v0 ad=0 pd=0 as=0 ps=0 w=1.83u l=0.5u
X1067 avdd hsn hs avdd pfet_05v0 ad=0 pd=0 as=0 ps=0 w=1.83u l=0.5u
X1068 hs hsn vss vss nfet_05v0 ad=0 pd=0 as=0 ps=0 w=1.32u l=0.6u
X1069 hs hsn avdd avdd pfet_05v0 ad=0 pd=0 as=0 ps=0 w=1.83u l=0.5u
X1070 hs hsn avdd avdd pfet_05v0 ad=0 pd=0 as=0 ps=0 w=1.83u l=0.5u
X1071 vss hsn hs vss nfet_05v0 ad=0 pd=0 as=0 ps=0 w=1.32u l=0.6u
X1072 vss hsn hs vss nfet_05v0 ad=0 pd=0 as=0 ps=0 w=1.32u l=0.6u
X1073 rb9 sr9 avdd avdd pfet_05v0 ad=18.1536p pd=78.4u as=0 ps=0 w=1.83u l=0.5u
X1074 avdd sr9 rb9 avdd pfet_05v0 ad=0 pd=0 as=0 ps=0 w=1.83u l=0.5u m=31
X1075 vss sr9 rb9 vss nfet_05v0 ad=0 pd=0 as=10.9824p ps=58.88u w=1.32u l=0.6u
X1077 vss sr9 rb9 vss nfet_05v0 ad=0 pd=0 as=0 ps=0 w=1.32u l=0.6u m=31
X1105 gb3 sg3 avdd avdd pfet_05v0 ad=0.8052p pd=4.54u as=0 ps=0 w=1.83u l=0.5u
X1106 gb3 sg3 vss vss nfet_05v0 ad=0.5808p pd=3.52u as=0 ps=0 w=1.32u l=0.6u
X1107 sr1 nr1 avdd avdd pfet_05v0 ad=0.8052p pd=4.54u as=0 ps=0 w=1.83u l=0.5u
X1108 sr1 nr1 vss vss nfet_05v0 ad=0.5808p pd=3.52u as=0 ps=0 w=1.32u l=0.6u
X1109 rb2 sr2 avdd avdd pfet_05v0 ad=0.8052p pd=4.54u as=0 ps=0 w=1.83u l=0.5u
X1110 rb2 sr2 vss vss nfet_05v0 ad=0.5808p pd=3.52u as=0 ps=0 w=1.32u l=0.6u
X1111 sr7 nr7 avdd avdd pfet_05v0 ad=4.5384p pd=19.6u as=0 ps=0 w=1.83u l=0.5u
X1112 vss nr7 sr7 vss nfet_05v0 ad=0 pd=0 as=2.7456p ps=14.72u w=1.32u l=0.6u
X1113 avdd nr7 sr7 avdd pfet_05v0 ad=0 pd=0 as=0 ps=0 w=1.83u l=0.5u
X1114 vss nr7 sr7 vss nfet_05v0 ad=0 pd=0 as=0 ps=0 w=1.32u l=0.6u
X1115 sr7 nr7 vss vss nfet_05v0 ad=0 pd=0 as=0 ps=0 w=1.32u l=0.6u
X1116 avdd nr7 sr7 avdd pfet_05v0 ad=0 pd=0 as=0 ps=0 w=1.83u l=0.5u
X1117 sr7 nr7 vss vss nfet_05v0 ad=0 pd=0 as=0 ps=0 w=1.32u l=0.6u
X1118 avdd nr7 sr7 avdd pfet_05v0 ad=0 pd=0 as=0 ps=0 w=1.83u l=0.5u
X1119 sr7 nr7 vss vss nfet_05v0 ad=0 pd=0 as=0 ps=0 w=1.32u l=0.6u
X1120 sr7 nr7 avdd avdd pfet_05v0 ad=0 pd=0 as=0 ps=0 w=1.83u l=0.5u
X1121 avdd nr7 sr7 avdd pfet_05v0 ad=0 pd=0 as=0 ps=0 w=1.83u l=0.5u
X1122 sr7 nr7 vss vss nfet_05v0 ad=0 pd=0 as=0 ps=0 w=1.32u l=0.6u
X1123 sr7 nr7 avdd avdd pfet_05v0 ad=0 pd=0 as=0 ps=0 w=1.83u l=0.5u
X1124 sr7 nr7 avdd avdd pfet_05v0 ad=0 pd=0 as=0 ps=0 w=1.83u l=0.5u
X1125 vss nr7 sr7 vss nfet_05v0 ad=0 pd=0 as=0 ps=0 w=1.32u l=0.6u
X1126 vss nr7 sr7 vss nfet_05v0 ad=0 pd=0 as=0 ps=0 w=1.32u l=0.6u
X1127 sr8 nr8 avdd avdd pfet_05v0 ad=9.0768p pd=39.2u as=0 ps=0 w=1.83u l=0.5u
X1128 avdd nr8 sr8 avdd pfet_05v0 ad=0 pd=0 as=0 ps=0 w=1.83u l=0.5u m=15
X1129 vss nr8 sr8 vss nfet_05v0 ad=0 pd=0 as=5.4912p ps=29.44u w=1.32u l=0.6u
X1131 vss nr8 sr8 vss nfet_05v0 ad=0 pd=0 as=0 ps=0 w=1.32u l=0.6u m=15
X1159 db8 d8 avdd avdd pfet_05v0 ad=0.8052p pd=4.54u as=0 ps=0 w=1.83u l=0.5u
X1160 db8 d8 vss vss nfet_05v0 ad=0.5808p pd=3.52u as=0 ps=0 w=1.32u l=0.6u
X1161 sr2 nr2 avdd avdd pfet_05v0 ad=0.8052p pd=4.54u as=0 ps=0 w=1.83u l=0.5u
X1162 sr2 nr2 vss vss nfet_05v0 ad=0.5808p pd=3.52u as=0 ps=0 w=1.32u l=0.6u
X1163 db4 d4 avdd avdd pfet_05v0 ad=0.8052p pd=4.54u as=0 ps=0 w=1.83u l=0.5u
X1164 db4 d4 vss vss nfet_05v0 ad=0.5808p pd=3.52u as=0 ps=0 w=1.32u l=0.6u
X1165 sr9 nr9 avdd avdd pfet_05v0 ad=18.1536p pd=78.4u as=0 ps=0 w=1.83u l=0.5u
X1166 avdd nr9 sr9 avdd pfet_05v0 ad=0 pd=0 as=0 ps=0 w=1.83u l=0.5u m=31
X1167 vss nr9 sr9 vss nfet_05v0 ad=0 pd=0 as=10.9824p ps=58.88u w=1.32u l=0.6u
X1169 vss nr9 sr9 vss nfet_05v0 ad=0 pd=0 as=0 ps=0 w=1.32u l=0.6u m=31
X1197 gb7 sg7 avdd avdd pfet_05v0 ad=0.8052p pd=4.54u as=0 ps=0 w=1.83u l=0.5u
X1198 gb7 sg7 vss vss nfet_05v0 ad=0.5808p pd=3.52u as=0 ps=0 w=1.32u l=0.6u
X1199 gb2 sg2 avdd avdd pfet_05v0 ad=0.8052p pd=4.54u as=0 ps=0 w=1.83u l=0.5u
X1200 gb2 sg2 vss vss nfet_05v0 ad=0.5808p pd=3.52u as=0 ps=0 w=1.32u l=0.6u
X1201 db2 d2 avdd avdd pfet_05v0 ad=0.8052p pd=4.54u as=0 ps=0 w=1.83u l=0.5u
X1202 db2 d2 vss vss nfet_05v0 ad=0.5808p pd=3.52u as=0 ps=0 w=1.32u l=0.6u
X1203 bs bsn avdd avdd pfet_05v0 ad=9.0768p pd=39.2u as=0 ps=0 w=1.83u l=0.5u
X1204 avdd bsn bs avdd pfet_05v0 ad=0 pd=0 as=0 ps=0 w=1.83u l=0.5u m=15
X1205 vss bsn bs vss nfet_05v0 ad=0 pd=0 as=5.4912p ps=29.44u w=1.32u l=0.6u
X1207 vss bsn bs vss nfet_05v0 ad=0 pd=0 as=0 ps=0 w=1.32u l=0.6u m=15
X1235 rb6 sr6 avdd avdd pfet_05v0 ad=0.5673p pd=2.45u as=0.5673p ps=2.45u w=1.83u l=0.5u
X1236 vss sr6 rb6 vss nfet_05v0 ad=0.5808p pd=3.52u as=0.3432p ps=1.84u w=1.32u l=0.6u
X1237 vss sr6 rb6 vss nfet_05v0 ad=0.3432p pd=1.84u as=0.3432p ps=1.84u w=1.32u l=0.6u
X1238 rb6 sr6 vss vss nfet_05v0 ad=0.3432p pd=1.84u as=0.3432p ps=1.84u w=1.32u l=0.6u
X1239 avdd sr6 rb6 avdd pfet_05v0 ad=0.5673p pd=2.45u as=0.5673p ps=2.45u w=1.83u l=0.5u
X1240 rb6 sr6 vss vss nfet_05v0 ad=0.3432p pd=1.84u as=0.5808p ps=3.52u w=1.32u l=0.6u
X1241 avdd sr6 rb6 avdd pfet_05v0 ad=0.8052p pd=4.54u as=0.5673p ps=2.45u w=1.83u l=0.5u
X1242 rb6 sr6 avdd avdd pfet_05v0 ad=0.5673p pd=2.45u as=0.8052p ps=4.54u w=1.83u l=0.5u
X1243 db7 d7 avdd avdd pfet_05v0 ad=0.8052p pd=4.54u as=0 ps=0 w=1.83u l=0.5u
X1244 db7 d7 vss vss nfet_05v0 ad=0.5808p pd=3.52u as=0 ps=0 w=1.32u l=0.6u
X1245 gb1 sg1 avdd avdd pfet_05v0 ad=0.8052p pd=4.54u as=0 ps=0 w=1.83u l=0.5u
X1246 gb1 sg1 vss vss nfet_05v0 ad=0.5808p pd=3.52u as=0 ps=0 w=1.32u l=0.6u
X1247 gb5 sg5 avdd avdd pfet_05v0 ad=0.8052p pd=4.54u as=0 ps=0 w=1.83u l=0.5u
X1248 gb5 sg5 vss vss nfet_05v0 ad=0.5808p pd=3.52u as=0 ps=0 w=1.32u l=0.6u
X1249 bsb bs avdd avdd pfet_05v0 ad=9.0768p pd=39.2u as=0 ps=0 w=1.83u l=0.5u
X1250 avdd bs bsb avdd pfet_05v0 ad=0 pd=0 as=0 ps=0 w=1.83u l=0.5u m=15
X1251 vss bs bsb vss nfet_05v0 ad=0 pd=0 as=5.4912p ps=29.44u w=1.32u l=0.6u
X1253 vss bs bsb vss nfet_05v0 ad=0 pd=0 as=0 ps=0 w=1.32u l=0.6u m=15
X1281 sr6 nr6 avdd avdd pfet_05v0 ad=2.2692p pd=9.8u as=0 ps=0 w=1.83u l=0.5u
X1282 vss nr6 sr6 vss nfet_05v0 ad=0 pd=0 as=1.3728p ps=7.36u w=1.32u l=0.6u
X1283 vss nr6 sr6 vss nfet_05v0 ad=0 pd=0 as=0 ps=0 w=1.32u l=0.6u
X1284 sr6 nr6 vss vss nfet_05v0 ad=0 pd=0 as=0 ps=0 w=1.32u l=0.6u
X1285 avdd nr6 sr6 avdd pfet_05v0 ad=0 pd=0 as=0 ps=0 w=1.83u l=0.5u
X1286 sr6 nr6 vss vss nfet_05v0 ad=0 pd=0 as=0 ps=0 w=1.32u l=0.6u
X1287 avdd nr6 sr6 avdd pfet_05v0 ad=0 pd=0 as=0 ps=0 w=1.83u l=0.5u
X1288 sr6 nr6 avdd avdd pfet_05v0 ad=0 pd=0 as=0 ps=0 w=1.83u l=0.5u
X1289 gb6 sg6 avdd avdd pfet_05v0 ad=0.8052p pd=4.54u as=0 ps=0 w=1.83u l=0.5u
X1290 gb6 sg6 vss vss nfet_05v0 ad=0.5808p pd=3.52u as=0 ps=0 w=1.32u l=0.6u
X1291 gb0 sg0 avdd avdd pfet_05v0 ad=0.8052p pd=4.54u as=0 ps=0 w=1.83u l=0.5u
X1292 gb0 sg0 vss vss nfet_05v0 ad=0.5808p pd=3.52u as=0 ps=0 w=1.32u l=0.6u
X1293 sg1 gn1 avdd avdd pfet_05v0 ad=0.8052p pd=4.54u as=0 ps=0 w=1.83u l=0.5u
X1294 sg1 gn1 vss vss nfet_05v0 ad=0.5808p pd=3.52u as=0 ps=0 w=1.32u l=0.6u
X1295 avdd hsg gn8 avdd pfet_05v0 ad=0 pd=0 as=1.4016p ps=7.76u w=1.46u l=0.5u
X1296 rv328_adcfe_p2_0/gf180mcu_fd_sc_mcu9t5v0__nand3_1_0/a_271_69# rb8 vss vss nfet_05v0 ad=0.4224p pd=3.28u as=0 ps=0 w=1.32u l=0.6u
X1297 rv328_adcfe_p2_0/gf180mcu_fd_sc_mcu9t5v0__nand3_1_0/a_455_69# hsg rv328_adcfe_p2_0/gf180mcu_fd_sc_mcu9t5v0__nand3_1_0/a_271_69# vss nfet_05v0 ad=0.5544p pd=3.48u as=0 ps=0 w=1.32u l=0.6u
X1298 gn8 db8 avdd avdd pfet_05v0 ad=0 pd=0 as=0 ps=0 w=1.46u l=0.5u
X1299 gn8 db8 rv328_adcfe_p2_0/gf180mcu_fd_sc_mcu9t5v0__nand3_1_0/a_455_69# vss nfet_05v0 ad=0.5808p pd=3.52u as=0 ps=0 w=1.32u l=0.6u
X1300 gn8 rb8 avdd avdd pfet_05v0 ad=0 pd=0 as=0 ps=0 w=1.46u l=0.5u
X1333 sg6 gn6 avdd avdd pfet_05v0 ad=2.2692p pd=9.8u as=0 ps=0 w=1.83u l=0.5u
X1334 vss gn6 sg6 vss nfet_05v0 ad=0 pd=0 as=1.3728p ps=7.36u w=1.32u l=0.6u
X1335 vss gn6 sg6 vss nfet_05v0 ad=0 pd=0 as=0 ps=0 w=1.32u l=0.6u
X1336 sg6 gn6 vss vss nfet_05v0 ad=0 pd=0 as=0 ps=0 w=1.32u l=0.6u
X1337 avdd gn6 sg6 avdd pfet_05v0 ad=0 pd=0 as=0 ps=0 w=1.83u l=0.5u
X1338 sg6 gn6 vss vss nfet_05v0 ad=0 pd=0 as=0 ps=0 w=1.32u l=0.6u
X1339 avdd gn6 sg6 avdd pfet_05v0 ad=0 pd=0 as=0 ps=0 w=1.83u l=0.5u
X1340 sg6 gn6 avdd avdd pfet_05v0 ad=0 pd=0 as=0 ps=0 w=1.83u l=0.5u
X1341 db0 d0 avdd avdd pfet_05v0 ad=0.8052p pd=4.54u as=0 ps=0 w=1.83u l=0.5u
X1342 db0 d0 vss vss nfet_05v0 ad=0.5808p pd=3.52u as=0 ps=0 w=1.32u l=0.6u
X1343 ab a avdd avdd pfet_05v0 ad=0.8052p pd=4.54u as=0 ps=0 w=1.83u l=0.5u
X1344 ab a vss vss nfet_05v0 ad=0.5808p pd=3.52u as=0 ps=0 w=1.32u l=0.6u
X1345 avdd hsg gn9 avdd pfet_05v0 ad=0 pd=0 as=1.4016p ps=7.76u w=1.46u l=0.5u
X1346 rv328_adcfe_p2_0/gf180mcu_fd_sc_mcu9t5v0__nand3_1_1/a_271_69# rb9 vss vss nfet_05v0 ad=0.4224p pd=3.28u as=0 ps=0 w=1.32u l=0.6u
X1347 rv328_adcfe_p2_0/gf180mcu_fd_sc_mcu9t5v0__nand3_1_1/a_455_69# hsg rv328_adcfe_p2_0/gf180mcu_fd_sc_mcu9t5v0__nand3_1_1/a_271_69# vss nfet_05v0 ad=0.5544p pd=3.48u as=0 ps=0 w=1.32u l=0.6u
X1348 gn9 db9 avdd avdd pfet_05v0 ad=0 pd=0 as=0 ps=0 w=1.46u l=0.5u
X1349 gn9 db9 rv328_adcfe_p2_0/gf180mcu_fd_sc_mcu9t5v0__nand3_1_1/a_455_69# vss nfet_05v0 ad=0.5808p pd=3.52u as=0 ps=0 w=1.32u l=0.6u
X1350 gn9 rb9 avdd avdd pfet_05v0 ad=0 pd=0 as=0 ps=0 w=1.46u l=0.5u
X1383 avdd q2 q3 avdd pfet_05v0 ad=0 pd=0 as=1.1895p ps=4.96u w=1.83u l=0.5u
X1384 q3 q2 vss vss nfet_05v0 ad=0.726p pd=3.74u as=0 ps=0 w=1.32u l=0.6u
X1385 vss q2 q3 vss nfet_05v0 ad=0 pd=0 as=0 ps=0 w=1.32u l=0.6u
X1386 q3 q2 avdd avdd pfet_05v0 ad=0 pd=0 as=0 ps=0 w=1.83u l=0.5u
X1387 db5 d5 avdd avdd pfet_05v0 ad=0.8052p pd=4.54u as=0 ps=0 w=1.83u l=0.5u
X1388 db5 d5 vss vss nfet_05v0 ad=0.5808p pd=3.52u as=0 ps=0 w=1.32u l=0.6u
X1389 avdd hs nr7 avdd pfet_05v0 ad=0 pd=0 as=1.4016p ps=7.76u w=1.46u l=0.5u
X1390 rv328_adcfe_p2_0/gf180mcu_fd_sc_mcu9t5v0__nand3_1_2/a_271_69# gb7 vss vss nfet_05v0 ad=0.4224p pd=3.28u as=0 ps=0 w=1.32u l=0.6u
X1391 rv328_adcfe_p2_0/gf180mcu_fd_sc_mcu9t5v0__nand3_1_2/a_455_69# hs rv328_adcfe_p2_0/gf180mcu_fd_sc_mcu9t5v0__nand3_1_2/a_271_69# vss nfet_05v0 ad=0.5544p pd=3.48u as=0 ps=0 w=1.32u l=0.6u
X1392 nr7 d7 avdd avdd pfet_05v0 ad=0 pd=0 as=0 ps=0 w=1.46u l=0.5u
X1393 nr7 d7 rv328_adcfe_p2_0/gf180mcu_fd_sc_mcu9t5v0__nand3_1_2/a_455_69# vss nfet_05v0 ad=0.5808p pd=3.52u as=0 ps=0 w=1.32u l=0.6u
X1394 nr7 gb7 avdd avdd pfet_05v0 ad=0 pd=0 as=0 ps=0 w=1.46u l=0.5u
X1427 avdd azb az avdd pfet_05v0 ad=0 pd=0 as=1.1895p ps=4.96u w=1.83u l=0.5u
X1428 az azb vss vss nfet_05v0 ad=0.726p pd=3.74u as=0 ps=0 w=1.32u l=0.6u
X1429 vss azb az vss nfet_05v0 ad=0 pd=0 as=0 ps=0 w=1.32u l=0.6u
X1430 az azb avdd avdd pfet_05v0 ad=0 pd=0 as=0 ps=0 w=1.83u l=0.5u
X1431 avdd hs nr9 avdd pfet_05v0 ad=0 pd=0 as=1.4016p ps=7.76u w=1.46u l=0.5u
X1432 rv328_adcfe_p2_0/gf180mcu_fd_sc_mcu9t5v0__nand3_1_3/a_271_69# gb9 vss vss nfet_05v0 ad=0.4224p pd=3.28u as=0 ps=0 w=1.32u l=0.6u
X1433 rv328_adcfe_p2_0/gf180mcu_fd_sc_mcu9t5v0__nand3_1_3/a_455_69# hs rv328_adcfe_p2_0/gf180mcu_fd_sc_mcu9t5v0__nand3_1_3/a_271_69# vss nfet_05v0 ad=0.5544p pd=3.48u as=0 ps=0 w=1.32u l=0.6u
X1434 nr9 d9 avdd avdd pfet_05v0 ad=0 pd=0 as=0 ps=0 w=1.46u l=0.5u
X1435 nr9 d9 rv328_adcfe_p2_0/gf180mcu_fd_sc_mcu9t5v0__nand3_1_3/a_455_69# vss nfet_05v0 ad=0.5808p pd=3.52u as=0 ps=0 w=1.32u l=0.6u
X1436 nr9 gb9 avdd avdd pfet_05v0 ad=0 pd=0 as=0 ps=0 w=1.46u l=0.5u
X1437 sg8 gn8 avdd avdd pfet_05v0 ad=9.0768p pd=39.2u as=0 ps=0 w=1.83u l=0.5u
X1438 avdd gn8 sg8 avdd pfet_05v0 ad=0 pd=0 as=0 ps=0 w=1.83u l=0.5u m=15
X1439 vss gn8 sg8 vss nfet_05v0 ad=0 pd=0 as=5.4912p ps=29.44u w=1.32u l=0.6u
X1441 vss gn8 sg8 vss nfet_05v0 ad=0 pd=0 as=0 ps=0 w=1.32u l=0.6u m=15
X1469 avdd ts0 ts avdd pfet_05v0 ad=0 pd=0 as=1.1895p ps=4.96u w=1.83u l=0.5u
X1470 ts ts0 vss vss nfet_05v0 ad=0.726p pd=3.74u as=0 ps=0 w=1.32u l=0.6u
X1471 vss ts0 ts vss nfet_05v0 ad=0 pd=0 as=0 ps=0 w=1.32u l=0.6u
X1472 ts ts0 avdd avdd pfet_05v0 ad=0 pd=0 as=0 ps=0 w=1.83u l=0.5u
X1473 avdd hs nr6 avdd pfet_05v0 ad=0 pd=0 as=1.4016p ps=7.76u w=1.46u l=0.5u
X1474 rv328_adcfe_p2_0/gf180mcu_fd_sc_mcu9t5v0__nand3_1_4/a_271_69# gb6 vss vss nfet_05v0 ad=0.4224p pd=3.28u as=0 ps=0 w=1.32u l=0.6u
X1475 rv328_adcfe_p2_0/gf180mcu_fd_sc_mcu9t5v0__nand3_1_4/a_455_69# hs rv328_adcfe_p2_0/gf180mcu_fd_sc_mcu9t5v0__nand3_1_4/a_271_69# vss nfet_05v0 ad=0.5544p pd=3.48u as=0 ps=0 w=1.32u l=0.6u
X1476 nr6 d6 avdd avdd pfet_05v0 ad=0 pd=0 as=0 ps=0 w=1.46u l=0.5u
X1477 nr6 d6 rv328_adcfe_p2_0/gf180mcu_fd_sc_mcu9t5v0__nand3_1_4/a_455_69# vss nfet_05v0 ad=0.5808p pd=3.52u as=0 ps=0 w=1.32u l=0.6u
X1478 nr6 gb6 avdd avdd pfet_05v0 ad=0 pd=0 as=0 ps=0 w=1.46u l=0.5u
X1479 dum ts vcm vss nfet_06v0 ad=1.5p pd=7u as=1.5p ps=7u w=3u l=0.7u
X1480 vcm vss cap_mim_2f0_m4m5_noshield c_width=25u c_length=25u
X1481 vcm vss cap_mim_2f0_m4m5_noshield c_width=25u c_length=25u
X1482 vcm vss cap_mim_2f0_m4m5_noshield c_width=25u c_length=25u
X1483 vcm vss cap_mim_2f0_m4m5_noshield c_width=25u c_length=25u
X1484 vt tsb avdd avdd pfet_06v0 ad=2.8p pd=10.56u as=5p ps=21u w=10u l=0.6u
X1485 vt tsb avdd avdd pfet_06v0 ad=2.8p pd=10.56u as=2.8p ps=10.56u w=10u l=0.6u
X1486 avdd tsb vt avdd pfet_06v0 ad=2.8p pd=10.56u as=2.8p ps=10.56u w=10u l=0.6u
X1487 avdd tsb vt avdd pfet_06v0 ad=5p pd=21u as=2.8p ps=10.56u w=10u l=0.6u
X1488 vcb ts vss vss nfet_06v0 ad=2.8p pd=10.56u as=5p ps=21u w=10u l=0.7u
X1489 vss ts vcb vss nfet_06v0 ad=5p pd=21u as=2.8p ps=10.56u w=10u l=0.7u
X1490 vt vcm vss ppolyf_u r_width=2u r_length=34.3u
X1491 top ts vcm vss nfet_06v0 ad=6p pd=25u as=6p ps=25u w=12u l=0.7u
X1492 vcm vcb vss ppolyf_u r_width=2u r_length=22.8u
C0 rb5 sg7 0.05532f
C1 ain rb9 0.07213f
C2 sg5 d0 0.03672f
C3 sg1 b2 0.13789f
C4 rb8 az 0.02582f
C5 q2 sg9 0.03437f
C6 rb4 sg6 0.05277f
C7 rv328_adcfe_p2_0/gf180mcu_fd_sc_mcu9t5v0__nand3_1_17/a_455_69# hs 0
C8 sg6 d7 0.06678f
C9 gn6 nr7 0.0029f
C10 sg9 gn1 0.02606f
C11 d5 ts0 0.01899f
C12 sg0 d2 0.02043f
C13 hsgs d0 0.00454f
C14 hs sr6 0.22231f
C15 nr2 sr9 0.029f
C16 gn0 sr7 0.01988f
C17 azn rb4 0.05702f
C18 d3 d8 0.0214f
C19 bs d4 0.01987f
C20 azn d7 0.05702f
C21 hsb bsb 0.02269f
C22 gn3 sr6 0.01988f
C23 hsb rb7 0.02458f
C24 sg3 bsb 0.33696f
C25 rv328_adcfe_p2_0/gf180mcu_fd_sc_mcu9t5v0__nand3_1_7/a_455_69# hs 0
C26 d1 sr6 0.0189f
C27 sg3 rb7 0.05426f
C28 azb q2 0.02797f
C29 db1 bsb 0
C30 nr0 d5 0.01739f
C31 sg8 sr6 0.06722f
C32 db1 rb7 0.02505f
C33 rv328_adcfe_p1_0/res1k_l60_n20_w1_0/a_n128_1500# ts 0
C34 rv328_adcfe_p2_0/gf180mcu_fd_sc_mcu9t5v0__nand3_1_8/a_455_69# hsg 0
C35 d9 sr6 0.02585f
C36 b4 rb2 0.12157f
C37 db9 bsb 0
C38 ain d4 0
C39 b5 rb7 0.03331f
C40 cmp azc 1.42538f
C41 b5 bsb 2.20925f
C42 rb9 gn6 0.02914f
C43 gn0 rb8 0.01437f
C44 b3 rb7 0.03442f
C45 b3 bsb 1.24323f
C46 sr6 b9 0.05338f
C47 en xcmp_b 0.06059f
C48 hs gn8 0.01437f
C49 sg7 sr6 0.10417f
C50 rb1 sg5 0.09451f
C51 d8 gb5 0.01437f
C52 bs rb6 0.15219f
C53 hs az 0.02582f
C54 sg8 gn8 7.11264f
C55 gb8 db8 1.98589f
C56 sg9 avdd 5.98326f
C57 d9 gn8 0.02621f
C58 db9 db8 0
C59 sr8 nr7 0.03384f
C60 rb5 sg6 0.05541f
C61 cmp xcmp_azd 0.55949f
C62 gb4 gb5 0.45665f
C63 sr5 ts 0.02117f
C64 d1 az 0.02582f
C65 rv328_adcfe_p2_0/gf180mcu_fd_sc_mcu9t5v0__nand3_1_2/a_455_69# nr7 0.01168f
C66 b6 rb6 3.03487f
C67 sg8 az 0.02582f
C68 bx avdd 0.63381f
C69 d9 az 0.02582f
C70 db3 d6 0.02685f
C71 b8 rb9 0.04928f
C72 azn rb5 0.05702f
C73 ain rb6 0.14838f
C74 xcmp_xm xcmp_azn 0.06879f
C75 sr5 sr0 0.04192f
C76 rb3 ts 0.02057f
C77 azb avdd 2.59262f
C78 gb6 d6 1.67442f
C79 rv328_adcfe_p2_0/gf180mcu_fd_sc_mcu9t5v0__nand3_1_17/a_271_69# hs 0.00297f
C80 rb6 db7 0
C81 nr3 sg5 0.01437f
C82 b0 ts 0
C83 sg7 az 0.02582f
C84 rb4 bsb 0.16316f
C85 hs gn0 0.02055f
C86 sr3 sg2 0.0638f
C87 sr4 sr2 0.0896f
C88 sg4 sg9 0.08281f
C89 rb9 sr8 0.03504f
C90 rb7 rb4 0.09258f
C91 sr1 rb2 0.12178f
C92 rb3 sr0 0.0699f
C93 d7 bsb 0.02247f
C94 sr7 nr7 3.68797f
C95 rb7 d7 0.15154f
C96 xcmp_vbi dum 8.69764f
C97 d1 gn0 0.04681f
C98 sg3 hsb 0.02458f
C99 b1 ts 0
C100 sg8 gn0 0.01988f
C101 b0 sr0 0.97315f
C102 gb5 nr6 0.00742f
C103 d9 gn0 0.01988f
C104 db1 sg3 0.02201f
C105 gb3 db2 0.00252f
C106 sr6 sg6 0.07439f
C107 rb6 gn6 0.13318f
C108 azb sg4 0.02642f
C109 sg2 ts0 0.01437f
C110 b1 sr0 0.12061f
C111 hsg b2 0.13497f
C112 rb8 nr7 0.02621f
C113 b5 sg3 0.07214f
C114 b3 sg3 1.26973f
C115 db9 gb8 0.28682f
C116 vt top 0
C117 rv328_adcfe_p2_0/gf180mcu_fd_sc_mcu9t5v0__nand3_1_5/a_271_69# avdd 0
C118 b7 sr4 0.13562f
C119 sr3 sg1 0.0563f
C120 azn sr6 0.05702f
C121 vrefp sr4 1.37548f
C122 ab d6 0.03727f
C123 d3 sr1 0.03944f
C124 d8 sr2 0.03176f
C125 rb1 nr2 0
C126 sr8 d4 0.01739f
C127 rb2 sr9 0.06269f
C128 gn0 sg7 0.01988f
C129 sg2 nr0 0.01739f
C130 sr7 rb9 0.0621f
C131 rb9 db2 0.03331f
C132 sample rb2 0
C133 bs sg0 0.31263f
C134 gb1 sg0 0.00485f
C135 b5 b3 0.20418f
C136 q2 ts 6.74433f
C137 b6 sg0 0.16449f
C138 sg9 d5 0.02296f
C139 rv328_adcfe_p2_0/gf180mcu_fd_sc_mcu9t5v0__nand3_1_2/a_271_69# nr7 0.00232f
C140 b8 rb6 0.07397f
C141 xcmp_x xcmp_o1 0.38539f
C142 rb5 bsb 0.15418f
C143 sr5 d2 0.01739f
C144 sg1 ts0 0.01437f
C145 rb5 rb7 0.1095f
C146 ain sg0 0.5321f
C147 sg6 az 0.02582f
C148 q2 sr0 0.03437f
C149 hsg db0 0.10342f
C150 rb9 rb8 23.8281f
C151 rb0 ab 0.03727f
C152 a rb2 0.04924f
C153 azb d5 0.02648f
C154 rv328_adcfe_p2_0/gf180mcu_fd_sc_mcu9t5v0__nand3_1_4/a_455_69# nr6 0.01168f
C155 xcmp_y top 0.08945f
C156 nr0 sg1 0.01739f
C157 azn az 3.68891f
C158 ab q3 0
C159 d4 db2 0.02685f
C160 sr8 rb6 0.09436f
C161 sr7 d4 0.01739f
C162 d3 sr9 0.0274f
C163 rb3 d2 0.01747f
C164 hsb rb4 0.02458f
C165 hsb d7 0.01895f
C166 hs nr7 1.37121f
C167 sg3 rb4 0.10318f
C168 sg3 d7 0.02043f
C169 db1 rb4 0.02505f
C170 rv328_adcfe_p2_0/gf180mcu_fd_sc_mcu9t5v0__nand3_1_0/a_455_69# gb9 0
C171 db1 d7 0.02505f
C172 b4 sr2 0.11349f
C173 sg8 nr7 0.02621f
C174 azb xds_n1 0.74484f
C175 ain gn4 0
C176 d9 nr7 0.02141f
C177 gb3 hs 1.07572f
C178 b5 rb4 0.09295f
C179 gn0 sg6 0.01988f
C180 d4 rb8 0.01739f
C181 rb2 d0 0.03672f
C182 gb3 gn3 0.1027f
C183 a d3 0.04933f
C184 avdd ts 2.43846f
C185 xds_n2 hs 0.12101f
C186 rv328_adcfe_p2_0/gf180mcu_fd_sc_mcu9t5v0__nand3_1_7/a_271_69# nr2 0.00232f
C187 gn2 d2 0
C188 sr7 rb6 0.06288f
C189 sr9 gb5 0.02844f
C190 sr6 bsb 0.11773f
C191 sr3 bsn 0.01988f
C192 rb7 sr6 0.06917f
C193 db2 rb6 0.02594f
C194 rv328_adcfe_p2_0/gf180mcu_fd_sc_mcu9t5v0__nand3_1_6/a_455_69# gn2 0.01168f
C195 hs rb9 0.26431f
C196 ain gb9 0
C197 sr0 avdd 1.18315f
C198 sg7 nr7 0.03561f
C199 xcmp_d1 xcmp_oc 0.19547f
C200 gn3 rb9 0.02247f
C201 gb0 sg0 2.652f
C202 d1 rb9 0.02508f
C203 b7 b4 0.10992f
C204 xcmp_o3 xcmp_o2 1.63033f
C205 rv328_adcfe_p2_0/gf180mcu_fd_sc_mcu9t5v0__nand3_1_9/a_455_69# avdd 0
C206 b4 vrefp 1.92895f
C207 sg8 rb9 0.41691f
C208 db6 d6 1.4825f
C209 b8 sg0 0.07942f
C210 d9 rb9 0
C211 azc xcmp_azn 17.24368f
C212 rb5 hsb 0.02458f
C213 xcmp_b avdd 1.17195f
C214 xcmp_n1 top 0.04953f
C215 q2 d2 0.02244f
C216 d3 d0 0.04081f
C217 rb6 rb8 0.07136f
C218 sg5 b2 0.04802f
C219 rb5 sg3 0.05479f
C220 sg4 ts 0.02057f
C221 dn rv328_adcfe_p1_0/res1k_l60_n20_w1_0/a_n128_3300# 0.0381f
C222 hs rv328_adcfe_p2_0/gf180mcu_fd_sc_mcu9t5v0__nand3_1_3/a_455_69# 0
C223 rb5 db1 0.02505f
C224 rb9 b9 17.44155f
C225 rv328_adcfe_p1_0/res1k_l60_n20_w1_0/a_12000_1200# rv328_adcfe_p1_0/res1k_l60_n20_w1_0/a_12000_600# 0.04819f
C226 d2 gn1 0.04622f
C227 rv328_adcfe_p2_0/gf180mcu_fd_sc_mcu9t5v0__nand3_1_4/a_271_69# nr6 0.00232f
C228 az bsb 0.02602f
C229 rb7 az 0.02582f
C230 xcmp_azn xcmp_azd 0.0925f
C231 hs d4 1.60122f
C232 sr3 hsg 0.18026f
C233 db3 sr4 0.0229f
C234 sr1 sr2 38.71737f
C235 sg0 sr8 0.11137f
C236 sg7 rb9 0.4026f
C237 sg2 sg9 0.07186f
C238 sg4 sr0 0.49029f
C239 rb1 rb2 35.84125f
C240 b5 rb5 1.9432f
C241 nr8 avdd 3.63389f
C242 rb4 d7 0.01835f
C243 d9 rv328_adcfe_p2_0/gf180mcu_fd_sc_mcu9t5v0__nand3_1_3/a_455_69# 0.00394f
C244 b3 rb5 0.03362f
C245 gb7 nr7 1.71124f
C246 gn3 d4 0.04779f
C247 xcmp_x xcmp_xm 0.93449f
C248 d1 d4 0.02297f
C249 nr5 sg9 0.02296f
C250 tsb sr5 0
C251 db8 gn8 5.31303f
C252 sg8 d4 0.01739f
C253 nr4 d6 0.01437f
C254 d9 d4 0.0214f
C255 gb2 rb1 0
C256 bs sr5 0.14199f
C257 azb sg2 0.02642f
C258 hsg ts0 0.01899f
C259 hsn sr3 0.02022f
C260 sg6 nr7 0.0012f
C261 b6 sr5 0.15868f
C262 b7 sr1 0.13562f
C263 d5 ts 0.02057f
C264 sg9 sg1 0.07059f
C265 vrefp sr1 1.11666f
C266 gn0 bsb 0.00139f
C267 rb1 d3 0.01907f
C268 hsg nr0 0.03977f
C269 hsgs db0 0
C270 hs rb6 0.20703f
C271 nr3 rb2 0
C272 hsb sr6 0.02464f
C273 gn4 sr8 0.01988f
C274 sr2 sr9 0.04226f
C275 sg0 sr7 0.06454f
C276 sample sr2 0.01745f
C277 sg7 d4 0.01739f
C278 gn0 rb7 0.01437f
C279 db3 d8 0.02685f
C280 ain sr5 0.2405f
C281 bs rb3 0.22636f
C282 d2 avdd 0.69787f
C283 rb9 gb7 0.0315f
C284 b0 tsb 0
C285 sg3 sr6 0.05628f
C286 gn3 rb6 0.01437f
C287 rv328_adcfe_p2_0/gf180mcu_fd_sc_mcu9t5v0__nand3_1_6/a_455_69# avdd 0
C288 gb4 db3 0.00252f
C289 db1 sr6 0.02201f
C290 d1 rb6 0.0189f
C291 xcmp_tail2 xcmp_b 0.15144f
C292 rv328_adcfe_p2_0/gf180mcu_fd_sc_mcu9t5v0__nand3_1_15/a_455_69# nr4 0.01168f
C293 b6 rb3 0.13651f
C294 sr0 d5 0.0348f
C295 sg8 rb6 0.10312f
C296 d8 gb6 0.02039f
C297 b1 tsb 0
C298 xcmp_enb xcmp_vbi 0.96829f
C299 bs b0 2.57547f
C300 d9 rb6 0.02144f
C301 rv328_adcfe_p2_0/gf180mcu_fd_sc_mcu9t5v0__nand3_1_9/a_271_69# avdd 0.00109f
C302 rv328_adcfe_p2_0/gf180mcu_fd_sc_mcu9t5v0__nand3_1_11/a_455_69# avdd 0
C303 gb2 nr3 0.00761f
C304 azb sg1 0.02642f
C305 xds_n1 ts 0.13081f
C306 rb5 rb4 35.1691f
C307 ain db4 0
C308 ain rb3 0.27978f
C309 rb5 d7 0.02107f
C310 cmp xcmp_azn 1.0844f
C311 xcmp_y xcmp_n1 0.6773f
C312 b0 b6 0.11398f
C313 bs b1 1.19756f
C314 sr4 ab 0.03727f
C315 rb9 sg6 0.27803f
C316 sg0 rb8 3.67358f
C317 xcmp_vbi xcmp_o1 0.26341f
C318 vbp xcmp_oc 3.19646f
C319 rb6 b9 0.04026f
C320 azn xds_n2 0.12154f
C321 a sr2 0.04924f
C322 hs rv328_adcfe_p2_0/gf180mcu_fd_sc_mcu9t5v0__nand3_1_3/a_271_69# 0.00297f
C323 b0 ain 30.65886f
C324 b6 b1 0.10891f
C325 vrefp sr9 23.8683f
C326 d3 nr3 5.33048f
C327 gn4 sr7 0.01988f
C328 sg7 rb6 0.05426f
C329 sg4 d2 0.01739f
C330 azn rb9 0.06105f
C331 xcmp_vb xcmp_b 0.06263f
C332 gb8 gn8 0.29988f
C333 hsb az 0
C334 ain b1 1.38297f
C335 db9 gn8 0.00379f
C336 sg3 az 0.02582f
C337 d9 rv328_adcfe_p2_0/gf180mcu_fd_sc_mcu9t5v0__nand3_1_3/a_271_69# 0.00139f
C338 rv328_adcfe_p2_0/gf180mcu_fd_sc_mcu9t5v0__nand3_1_7/a_271_69# gb2 0.00292f
C339 q2 tsb 0.04604f
C340 ain gn2 0
C341 d8 ab 0.03727f
C342 sr2 d0 0.04146f
C343 d4 sg6 0.01739f
C344 gn4 rb8 0.01437f
C345 bs q2 0.01952f
C346 rv328_adcfe_p1_0/res1k_l60_n20_w1_0/a_n128_300# ts 0.05537f
C347 gb6 nr6 1.32634f
C348 gb2 rv328_adcfe_p2_0/gf180mcu_fd_sc_mcu9t5v0__nand3_1_8/a_455_69# 0
C349 b8 sr5 0.07492f
C350 azn d4 0.06209f
C351 gb1 gn1 0.10277f
C352 rb4 sr6 0.05268f
C353 sr3 sg5 0.07117f
C354 sg9 bsn 0.01988f
C355 rb6 gb7 0
C356 sr6 d7 0.03576f
C357 hs sg0 0.10501f
C358 avdd dum 4.68337f
C359 rb7 nr7 0.14498f
C360 ain q2 0
C361 sg3 gn0 0.01988f
C362 d1 sg0 0.22744f
C363 db1 gn0 0
C364 d2 d5 0.02237f
C365 sg8 sg0 0.11994f
C366 ain gn1 0
C367 rv328_adcfe_p2_0/gf180mcu_fd_sc_mcu9t5v0__nand3_1_15/a_271_69# nr4 0.00232f
C368 hsgs sr3 0
C369 rb0 d6 0.02026f
C370 b8 rb3 0.07418f
C371 d9 sg0 0.02043f
C372 xcmp_enb en 0.65108f
C373 azb bsn 0.00913f
C374 sr5 sr8 0.10154f
C375 sg5 ts0 0.01437f
C376 rv328_adcfe_p2_0/gf180mcu_fd_sc_mcu9t5v0__nand3_1_11/a_271_69# avdd 0.00109f
C377 rb6 sg6 0.08879f
C378 sg9 nr9 0.08239f
C379 sg2 ts 0.02057f
C380 q3 d6 0.05063f
C381 sg0 b9 0.04957f
C382 b0 b8 0.19327f
C383 xcmp_tail xcmp_b 4.37952f
C384 en xcmp_o1 1.33196f
C385 tsb avdd 13.76619f
C386 nr0 sg5 0.01739f
C387 azn rb6 0.05702f
C388 azc xds_n2 0.33486f
C389 hsgs ts0 0
C390 rb4 az 0.02582f
C391 rb9 bsb 6.92018f
C392 hs gn4 0.02108f
C393 sg0 sg7 0.06576f
C394 b8 b1 0.18384f
C395 d7 az 0.02582f
C396 sg9 hsg 0.25337f
C397 sr8 db4 0.0229f
C398 rb3 sr8 0.09335f
C399 rb1 sr2 0.12038f
C400 sg2 sr0 0.4175f
C401 rb7 rb9 0.08574f
C402 gn7 avdd 2.16178f
C403 bs avdd 6.37479f
C404 azc xcmp_x 0.06931f
C405 gb1 avdd 0.62464f
C406 bx hsg 24.63752f
C407 sg8 gn4 0.01988f
C408 sg9 db5 0.05863f
C409 rb0 q3 0.05352f
C410 hsgs nr0 0
C411 b0 sr8 0.04577f
C412 nr1 d6 0.01437f
C413 b6 avdd 4.30793f
C414 d9 gn4 0.02022f
C415 rb5 sr6 0.06017f
C416 rv328_adcfe_p2_0/gf180mcu_fd_sc_mcu9t5v0__nand3_1_10/a_455_69# db0 0.00394f
C417 sr5 sr7 0.06962f
C418 sr5 db2 0.0229f
C419 sg1 ts 0.02057f
C420 gn5 sg9 0.0255f
C421 ain avdd 27.34624f
C422 azb hsg 0.02642f
C423 hs gb9 0.75932f
C424 b1 sr8 0.04493f
C425 rb9 db8 0.03925f
C426 hsn sg9 0.02022f
C427 rb2 b2 2.1145f
C428 xcmp_tail2 dum 0.13149f
C429 b7 rb1 0.13589f
C430 sg8 gb9 0.00985f
C431 sr0 sg1 0.35704f
C432 vrefp rb1 0.68665f
C433 d4 bsb 0.02424f
C434 rb3 sr7 0.05268f
C435 sg7 gn4 0.01988f
C436 gn0 rb4 0.01437f
C437 bs sg4 0.13299f
C438 nr4 sr4 2.88141f
C439 d9 gb9 0.05956f
C440 rb0 nr1 0
C441 sr7 db4 0.0229f
C442 gn2 sr8 0.01988f
C443 db3 sr9 0.03291f
C444 sr3 nr2 0.01899f
C445 rb7 d4 0.01739f
C446 rb3 db2 0.02594f
C447 gn0 d7 0.01988f
C448 db7 avdd 0.50476f
C449 sr5 rb8 0.10191f
C450 b6 sg4 0.13651f
C451 sr9 gb6 0.03212f
C452 rb5 az 0.02582f
C453 ain sg4 0.22175f
C454 q2 sr8 0.03437f
C455 sg0 sg6 0.06621f
C456 sr1 ab 0.03727f
C457 rb3 rb8 0.05358f
C458 db4 rb8 0.02594f
C459 gb3 sg3 2.05962f
C460 gn6 avdd 1.31062f
C461 rv328_adcfe_p2_0/gf180mcu_fd_sc_mcu9t5v0__nand3_1_5/a_271_69# hsg 0.00297f
C462 sr8 gn1 0.01988f
C463 rv328_adcfe_p2_0/gf180mcu_fd_sc_mcu9t5v0__nand3_1_0/a_271_69# avdd 0
C464 rb6 bsb 0.15343f
C465 sr7 gn2 0.01988f
C466 azn sg0 0.06105f
C467 gn2 db2 2.39165f
C468 sg2 d2 0.0248f
C469 rb7 rb6 31.53105f
C470 nr4 d8 0.01437f
C471 rv328_adcfe_p2_0/gf180mcu_fd_sc_mcu9t5v0__nand3_1_5/a_271_69# db5 0.00139f
C472 hsb rb9 0.02861f
C473 gb4 nr4 0.23062f
C474 sg3 rb9 0.35713f
C475 db1 rb9 0.03123f
C476 gn5 rv328_adcfe_p2_0/gf180mcu_fd_sc_mcu9t5v0__nand3_1_5/a_271_69# 0.00232f
C477 bs d5 0.01976f
C478 gb0 avdd 0.73334f
C479 gb8 rb9 0.03912f
C480 db6 nr6 0.43591f
C481 db9 rb9 0.08065f
C482 rb5 gn0 0.01437f
C483 b8 avdd 7.10048f
C484 en xcmp_xm 0.39416f
C485 bsn ts 0.00118f
C486 sr5 hs 0.22165f
C487 b5 rb9 0
C488 q2 sr7 0.03437f
C489 rv328_adcfe_p2_0/gf180mcu_fd_sc_mcu9t5v0__nand3_1_10/a_271_69# db0 0.00139f
C490 sample ab 0
C491 sr9 ab 0.61806f
C492 gn4 sg6 0.01988f
C493 gn2 rb8 0.01437f
C494 sr5 gn3 0.01988f
C495 sr5 d1 0.0189f
C496 ain d5 0
C497 d2 sg1 0.2396f
C498 db2 gn1 0
C499 sr5 sg8 0.06018f
C500 sr7 gn1 0.01988f
C501 xcmp_o2 xcmp_b 0.17002f
C502 sr6 az 0.02593f
C503 azb q1 0.00279f
C504 sg9 sg5 0.0769f
C505 sr0 bsn 0.01988f
C506 sr5 d9 0.01899f
C507 hsb d4 0.01895f
C508 hs rb3 0.1693f
C509 hs db4 0.77775f
C510 rv328_adcfe_p2_0/gf180mcu_fd_sc_mcu9t5v0__nand3_1_13/a_455_69# avdd 0
C511 sr8 avdd 6.50184f
C512 gn3 rb3 0.05683f
C513 sg3 d4 0.26364f
C514 db9 rv328_adcfe_p2_0/gf180mcu_fd_sc_mcu9t5v0__nand3_1_3/a_455_69# 0
C515 gn3 db4 0
C516 d7 nr7 1.42493f
C517 bx sg5 0.04382f
C518 db1 d4 0.02505f
C519 d1 rb3 0.0189f
C520 q2 rb8 0.03965f
C521 sr5 b9 0.04328f
C522 xcmp_tail dum 4.17706f
C523 sg8 rb3 0.10163f
C524 sg8 db4 0.0229f
C525 sg9 gn9 15.5018f
C526 a ab 0.76535f
C527 sr4 d6 0.03176f
C528 b8 sg4 0.06515f
C529 d9 rb3 0.01858f
C530 d9 db4 0.02685f
C531 gn1 rb8 0.01437f
C532 azb sg5 0.02642f
C533 sr5 sg7 0.08772f
C534 hsg ts 0.02057f
C535 b0 sg8 0.05351f
C536 rb3 b9 0.04026f
C537 rv328_adcfe_p2_0/gf180mcu_fd_sc_mcu9t5v0__nand3_1_10/a_455_69# nr0 0
C538 gn0 sr6 0.01988f
C539 b1 sg8 0.05266f
C540 sg0 bsb 0.38371f
C541 hs gn2 0.02108f
C542 hsg sr0 0.11499f
C543 sg4 sr8 0.09728f
C544 sr3 rb2 0.06005f
C545 rb0 sr4 0.10393f
C546 rb3 sg7 0.05268f
C547 sg7 db4 0.0229f
C548 sg0 rb7 3.75139f
C549 rb4 rb9 0.06932f
C550 hsb rb6 0.02458f
C551 sr7 avdd 3.35762f
C552 db2 avdd 0.44748f
C553 rb9 d7 0.02895f
C554 b0 b9 0.04289f
C555 sg3 rb6 0.05517f
C556 db1 rb6 0.02505f
C557 d0 ab 0.04588f
C558 sg8 gn2 0.01988f
C559 azc xcmp_vbi 0.15758f
C560 sr4 q3 0.04545f
C561 xcmp_enb avdd 1.88457f
C562 b1 b9 0.04295f
C563 d8 d6 0.02057f
C564 d9 gn2 0.02022f
C565 b5 rb6 0.05327f
C566 b3 rb6 0.0339f
C567 rb2 ts0 0.01899f
C568 q2 hs 12.31823f
C569 xcmp_o1 avdd 0.77794f
C570 hsn sr0 0.02022f
C571 rb8 avdd 14.50816f
C572 sr2 b2 1.68871f
C573 q2 d1 0.02242f
C574 rv328_adcfe_p2_0/gf180mcu_fd_sc_mcu9t5v0__nand2_1_0/a_245_69# ab 0
C575 hs gn1 0.01993f
C576 d2 bsn 0.02042f
C577 xcmp_vbi xcmp_azd 0.12201f
C578 q2 sg8 0.03437f
C579 xcmp_o3 xcmp_oc 0.08998f
C580 gn4 bsb 0.00139f
C581 rb4 d4 0.02993f
C582 hsg nr8 0.02991f
C583 db3 nr3 0.14981f
C584 d3 sr3 0.02656f
C585 sg4 sr7 0.05668f
C586 sr4 nr1 0.01899f
C587 sg7 gn2 0.01988f
C588 sg9 nr2 0.02055f
C589 sg4 db2 0.0229f
C590 gn4 rb7 0.01437f
C591 rb0 d8 0.02062f
C592 nr0 rb2 0.01739f
C593 bs sg2 0.16405f
C594 q2 d9 0.02335f
C595 d4 d7 0.02237f
C596 d1 gn1 0
C597 sr5 sg6 0.09696f
C598 rv328_adcfe_p2_0/gf180mcu_fd_sc_mcu9t5v0__nand3_1_13/a_271_69# avdd 0.00109f
C599 sg8 gn1 0.01988f
C600 rv328_adcfe_p2_0/gf180mcu_fd_sc_mcu9t5v0__nand3_1_13/a_455_69# d5 0.00394f
C601 db9 rv328_adcfe_p2_0/gf180mcu_fd_sc_mcu9t5v0__nand3_1_3/a_271_69# 0
C602 b6 sg2 0.13651f
C603 d9 gn1 0.01899f
C604 d8 q3 0.05063f
C605 sr8 d5 0.01988f
C606 rv328_adcfe_p2_0/gf180mcu_fd_sc_mcu9t5v0__nand3_1_2/a_271_69# avdd 0
C607 ain sg2 0.30791f
C608 azn sr5 0.05702f
C609 rb5 rb9 0.07603f
C610 rv328_adcfe_p2_0/gf180mcu_fd_sc_mcu9t5v0__nand3_1_8/a_271_69# gn1 0.00232f
C611 b7 b2 0.10817f
C612 gb9 bsb 0
C613 d3 ts0 0.01901f
C614 q2 sg7 0.03437f
C615 vrefp b2 1.34347f
C616 sg4 rb8 0.10511f
C617 rb3 sg6 0.05276f
C618 rb1 ab 0.03727f
C619 db4 sg6 0.0229f
C620 ain nr5 0
C621 d6 nr6 1.38284f
C622 sg7 gn1 0.01988f
C623 bs sg1 0.16521f
C624 d3 nr0 0.0174f
C625 nr1 d8 0.01437f
C626 hsg d2 0.05615f
C627 nr4 sr9 0.029f
C628 rb4 rb6 0.10296f
C629 azn rb3 0.05702f
C630 q1 ts 0.08939f
C631 gb1 sg1 2.45467f
C632 rv328_adcfe_p2_0/gf180mcu_fd_sc_mcu9t5v0__nand3_1_10/a_271_69# nr0 0.00119f
C633 rb6 d7 0.03117f
C634 hsb sg0 0.02861f
C635 rv328_adcfe_p2_0/gf180mcu_fd_sc_mcu9t5v0__nand3_1_6/a_455_69# hsg 0
C636 hs avdd 5.68186f
C637 sg3 sg0 0.12497f
C638 b6 sg1 0.13651f
C639 rv328_adcfe_p2_0/gf180mcu_fd_sc_mcu9t5v0__nand3_1_18/a_455_69# nr8 0.01168f
C640 gn3 avdd 0.91026f
C641 db8 gb9 0.00102f
C642 db1 sg0 0.97653f
C643 db2 d5 0.02685f
C644 sr7 d5 0.01988f
C645 d1 avdd 3.66398f
C646 xcmp_tail2 xcmp_o1 1.35518f
C647 b4 rb0 0.12205f
C648 ain sg1 0.2968f
C649 sg8 avdd 2.87812f
C650 azc en 2.75971f
C651 cmp xcmp_vbi 0.05401f
C652 rb5 d4 0.01747f
C653 d9 avdd 1.11032f
C654 b5 sg0 0.09295f
C655 sg5 ts 0.02057f
C656 gn2 sg6 0.01988f
C657 b3 sg0 0.09682f
C658 hsn d2 0.02022f
C659 rv328_adcfe_p2_0/gf180mcu_fd_sc_mcu9t5v0__nand3_1_8/a_271_69# avdd 0.00109f
C660 db9 rv328_adcfe_p2_0/gf180mcu_fd_sc_mcu9t5v0__nand3_1_1/a_455_69# 0.00394f
C661 avdd b9 12.45424f
C662 xcmp_a top 0.0992f
C663 rb8 d5 0.01437f
C664 sr0 sg5 0.62728f
C665 rb9 sr6 0.04952f
C666 hsgs ts 0.00977f
C667 en xcmp_azd 1.51738f
C668 hs sg4 0.19491f
C669 sg7 avdd 2.01811f
C670 xcmp_vb xcmp_o1 1.14498f
C671 xcmp_x xcmp_azn 0
C672 rv328_adcfe_p2_0/gf180mcu_fd_sc_mcu9t5v0__nand3_1_16/a_271_69# rb3 0.00292f
C673 gn3 sg4 0.01988f
C674 d1 sg4 0.0189f
C675 q2 sg6 0.03437f
C676 rv328_adcfe_p1_0/res1k_l60_n20_w1_0/a_n128_2700# rv328_adcfe_p1_0/res1k_l60_n20_w1_0/a_n128_3300# 0.04819f
C677 sg8 sg4 0.11044f
C678 rv328_adcfe_p2_0/gf180mcu_fd_sc_mcu9t5v0__nand3_1_13/a_271_69# d5 0.00139f
C679 sr1 d6 0.03944f
C680 b8 sg2 0.06515f
C681 d9 sg4 0.02043f
C682 rb5 rb6 33.9378f
C683 bs rv328_adcfe_p2_0/gf180mcu_fd_sc_mcu9t5v0__nand3_1_12/a_455_69# 0
C684 gn1 sg6 0.01988f
C685 sr5 bsb 0.11073f
C686 sr5 rb7 0.05229f
C687 rv328_adcfe_p2_0/gf180mcu_fd_sc_mcu9t5v0__nand3_1_15/a_271_69# gb4 0.00292f
C688 azn q2 0.06127f
C689 rb9 gn8 0.04019f
C690 tsb bsn 0.00116f
C691 sg4 b9 0.04122f
C692 gb8 gb9 0
C693 d4 sr6 0.01739f
C694 bs bsn 6.65018f
C695 rb9 az 0.02986f
C696 db4 bsb 0
C697 rb3 bsb 0.19373f
C698 db9 gb9 6.17891f
C699 rb0 sr1 0.12469f
C700 sg2 sr8 0.09686f
C701 sr3 sr2 38.5206f
C702 sg7 sg4 0.06974f
C703 sg9 rb2 0.06005f
C704 sg0 rb4 0.53502f
C705 rb3 rb7 0.09178f
C706 rb7 db4 0.02594f
C707 sg0 d7 0.02043f
C708 rv328_adcfe_p2_0/gf180mcu_fd_sc_mcu9t5v0__nand3_1_16/a_455_69# avdd 0
C709 gb7 avdd 0.89825f
C710 nr5 rv328_adcfe_p2_0/gf180mcu_fd_sc_mcu9t5v0__nand3_1_13/a_455_69# 0.01168f
C711 nr5 sr8 0.01437f
C712 rv328_adcfe_p2_0/gf180mcu_fd_sc_mcu9t5v0__nand3_1_17/a_271_69# gb3 0.00292f
C713 bx rb2 0.0202f
C714 b8 sg1 0.06515f
C715 hs d5 0.11028f
C716 rv328_adcfe_p2_0/gf180mcu_fd_sc_mcu9t5v0__nand3_1_18/a_271_69# nr8 0.00232f
C717 sr1 q3 0.04545f
C718 b0 rb7 0.03721f
C719 b0 bsb 0.84254f
C720 sr9 d6 0.02763f
C721 gn3 d5 0.02022f
C722 ain bsn 0.00447f
C723 d1 d5 0.02233f
C724 cmp en 0.04563f
C725 azb rb2 0.02642f
C726 sg8 d5 0.01437f
C727 b1 bsb 1.09397f
C728 sr2 ts0 0.01437f
C729 b1 rb7 0.03648f
C730 d9 d5 0.01531f
C731 sg6 avdd 2.45839f
C732 hsg rv328_adcfe_p2_0/gf180mcu_fd_sc_mcu9t5v0__nand3_1_0/a_455_69# 0
C733 rv328_adcfe_p1_0/res1k_l60_n20_w1_0/a_12000_2400# rv328_adcfe_p1_0/res1k_l60_n20_w1_0/a_12000_1800# 0.04819f
C734 en b3 0
C735 b7 sr3 0.13562f
C736 xcmp_y xcmp_a 0.33407f
C737 xcmp_tail xcmp_o1 0.00137f
C738 rv328_adcfe_p1_0/res1k_l60_n20_w1_0/a_n128_2100# dn 0.0381f
C739 sr6 rb6 1.10676f
C740 xds_n1 hs 0.13136f
C741 sr8 sg1 0.09686f
C742 d2 sg5 0.01739f
C743 vrefp sr3 1.01917f
C744 db9 rv328_adcfe_p2_0/gf180mcu_fd_sc_mcu9t5v0__nand3_1_1/a_271_69# 0.00139f
C745 d4 az 0.02582f
C746 gn2 bsb 0.0014f
C747 gn4 rb4 0.05683f
C748 gn7 hsg 1.35047f
C749 nr1 sr1 2.70929f
C750 sg2 db2 0.69295f
C751 sr7 sg2 0.05619f
C752 rb0 sr9 0.07088f
C753 nr0 sr2 0.0229f
C754 d3 sg9 0.02476f
C755 rb7 gn2 0.01437f
C756 gn0 rb9 0.01841f
C757 sample rb0 0
C758 sr4 d8 0.03176f
C759 bs hsg 0.19982f
C760 gn4 d7 0.02022f
C761 azn avdd 2.08656f
C762 a d6 0.04928f
C763 gb1 hsg 0.02749f
C764 ain nr9 0.00366f
C765 nr5 sr7 0.01437f
C766 b6 hsg 0.13793f
C767 sg7 d5 0.01437f
C768 sr9 q3 0.06332f
C769 d1b dn 0.05192f
C770 ain hsg 0.43135f
C771 rb5 sg0 0.70239f
C772 vbp top 10.48988f
C773 azb d3 0.02654f
C774 sr5 hsb 0.02463f
C775 q2 bsb 0.02613f
C776 sg4 sg6 0.08276f
C777 sg2 rb8 0.10407f
C778 q2 rb7 0.0402f
C779 sr5 sg3 0.0563f
C780 bs hsn 0.00637f
C781 a rb0 0.04924f
C782 sr5 db1 0.02201f
C783 xcmp_xm xcmp_vb 1.3879f
C784 ain db5 0
C785 azc q2 0.10945f
C786 nr5 rb8 0.01437f
C787 gn1 bsb 0.00138f
C788 db2 sg1 1.04856f
C789 sr7 sg1 0.05619f
C790 rb7 gn1 0.01437f
C791 rb6 az 0.02582f
C792 gn0 d4 0.01988f
C793 hsg db7 0.17874f
C794 nr1 sr9 0.029f
C795 sg9 gb5 0.02736f
C796 azn sg4 0.05702f
C797 d0 d6 0.04004f
C798 ain gn5 0
C799 hsb rb3 0.02458f
C800 b5 sr5 1.26775f
C801 sg3 rb3 0.06611f
C802 sg3 db4 1.19263f
C803 ain hsn 0
C804 rv328_adcfe_p2_0/gf180mcu_fd_sc_mcu9t5v0__nand3_1_16/a_271_69# avdd 0.00109f
C805 db1 rb3 0.02505f
C806 nr5 rv328_adcfe_p2_0/gf180mcu_fd_sc_mcu9t5v0__nand3_1_13/a_271_69# 0.00232f
C807 b4 sr4 2.13528f
C808 rb5 gn4 0.02335f
C809 b0 sg3 0.0466f
C810 sg1 rb8 0.10447f
C811 b5 rb3 0.07214f
C812 xcmp_n1 xcmp_a 0.05317f
C813 hsg gn6 4.7172f
C814 rb0 d0 1.10844f
C815 b3 rb3 1.01383f
C816 b1 sg3 0.04651f
C817 hsg rv328_adcfe_p2_0/gf180mcu_fd_sc_mcu9t5v0__nand3_1_0/a_271_69# 0.00297f
C818 b0 b5 0.17151f
C819 d0 q3 0.06821f
C820 sg6 d5 0.01437f
C821 nr2 d2 5.37986f
C822 sg0 sr6 0.06454f
C823 sr8 bsn 0.01988f
C824 gn0 rb6 0.01437f
C825 b0 b3 0.16254f
C826 hs sg2 0.14768f
C827 avdd bsb 66.87767f
C828 rb7 avdd 10.64452f
C829 rb9 nr7 0.03561f
C830 sg3 gn2 0.01988f
C831 b5 b1 0.16639f
C832 azn d5 0.06165f
C833 nr5 hs 4.75183f
C834 d1 sg2 0.0189f
C835 b3 b1 0.19108f
C836 gb0 hsg 0.02726f
C837 azc avdd 7.48218f
C838 xcmp_y xcmp_ym 0.54037f
C839 xcmp_vbi xcmp_azn 0.06076f
C840 sg8 sg2 0.10566f
C841 rb1 d6 0.0192f
C842 b8 hsg 0.09221f
C843 d8 nr6 0.02034f
C844 d9 sg2 0.02043f
C845 nr5 sg8 0.01437f
C846 sr5 rb4 0.06133f
C847 vbp xcmp_y 0.11245f
C848 sr5 d7 0.01899f
C849 rb2 ts 0.02057f
C850 nr5 d9 0.02043f
C851 xcmp_enb xcmp_o2 2.60221f
C852 q2 hsb 0.46347f
C853 db8 avdd 0.7041f
C854 sg2 b9 0.04122f
C855 q2 sg3 0.03437f
C856 azn xds_n1 0.13151f
C857 xcmp_azd avdd 6.02123f
C858 hs sg1 0.12359f
C859 gn4 sr6 0.01988f
C860 sr7 bsn 0.01988f
C861 bs sg5 0.19774f
C862 nr5 b9 0
C863 xcmp_o2 xcmp_o1 0.44025f
C864 sg0 az 0.02986f
C865 rb4 db4 0.06733f
C866 hsg sr8 0.28865f
C867 db3 sr3 0.04037f
C868 sg9 sr2 0.48852f
C869 sg4 rb7 0.05519f
C870 sg7 sg2 0.0586f
C871 sg3 gn1 0.01988f
C872 sr4 sr1 0.08266f
C873 sg4 bsb 0.15974f
C874 rb3 rb4 35.71138f
C875 rb1 rb0 36.32447f
C876 sr0 rb2 0.12121f
C877 rb3 d7 0.01842f
C878 db4 d7 0.02685f
C879 db1 gn1 2.58917f
C880 tsb hsgs 0
C881 d1 sg1 0.02515f
C882 b6 sg5 0.14623f
C883 nr5 sg7 0.01437f
C884 sg8 sg1 0.10552f
C885 bx sr2 0.04626f
C886 d9 sg1 0.02043f
C887 sr8 db5 0.0411f
C888 rb1 q3 0.04545f
C889 nr3 d6 0.01437f
C890 bs hsgs 0.02952f
C891 ain sg5 0.22185f
C892 d1b a 0.78957f
C893 gb3 d4 0.00711f
C894 bsn rb8 0.01988f
C895 gn5 sr8 0.01656f
C896 azb sr2 0.02642f
C897 d3 ts 0.02057f
C898 sg1 b9 0.04122f
C899 hsn sr8 0.02027f
C900 ain gn9 0.00511f
C901 rv328_adcfe_p2_0/gf180mcu_fd_sc_mcu9t5v0__nand3_1_19/a_455_69# gn7 0.01168f
C902 sg7 sg1 0.05786f
C903 vrefp sg9 2.23112f
C904 d3 sr0 0.03481f
C905 sr1 d8 0.03944f
C906 azc xcmp_tail2 0
C907 hsg db2 0.13623f
C908 gn0 sg0 2.57573f
C909 rb1 nr1 0.05658f
C910 sr7 hsg 0.22092f
C911 sr4 sr9 0.04543f
C912 sample sr4 0.01739f
C913 rb9 d4 0.02598f
C914 gn2 rb4 0.01437f
C915 xcmp_ym xcmp_n1 0
C916 rb5 sr5 2.75621f
C917 gn2 d7 0.02022f
C918 b7 bx 0.20784f
C919 hsb avdd 0.43035f
C920 bx vrefp 0.38038f
C921 rv328_adcfe_p2_0/gf180mcu_fd_sc_mcu9t5v0__nand3_1_18/a_455_69# sr8 0
C922 sg3 avdd 1.01391f
C923 vbp xcmp_n1 0.0611f
C924 gn8 gb9 0.00839f
C925 d5 bsb 0.02405f
C926 sr7 db5 0.0411f
C927 rb7 d5 0.01437f
C928 db1 avdd 0.44352f
C929 cmp avdd 1.78972f
C930 gb8 avdd 0.91233f
C931 en xcmp_azn 16.83906f
C932 rb5 rb3 0.10562f
C933 rb5 db4 0.02594f
C934 db9 avdd 0.53469f
C935 gn5 sr7 0.01656f
C936 hsg rb8 1.39293f
C937 sr3 ab 0.03727f
C938 sg2 sg6 0.05995f
C939 q2 rb4 0.04309f
C940 b5 avdd 5.76571f
C941 hsn sr7 0.02027f
C942 q2 d7 0.0227f
C943 b3 avdd 2.53264f
C944 a sr4 0.04924f
C945 azc xcmp_vb 0.68879f
C946 b0 rb5 0.0344f
C947 rv328_adcfe_p2_0/gf180mcu_fd_sc_mcu9t5v0__nand3_1_19/a_455_69# db7 0.00394f
C948 nr5 sg6 0.01437f
C949 rb4 gn1 0.01437f
C950 gn1 d7 0.01899f
C951 rb8 db5 0.04414f
C952 rb2 d2 0.02871f
C953 hs bsn 0.02021f
C954 d8 sr9 0.0776f
C955 azn sg2 0.05702f
C956 rb9 rb6 0.07877f
C957 hsb sg4 0.02458f
C958 gb1 nr2 0.00761f
C959 azc xds_n1 0.13172f
C960 b1 rb5 0.03419f
C961 d1 bsn 0.02049f
C962 sg3 sg4 38.11921f
C963 gn5 rb8 0.01656f
C964 ab ts0 0
C965 db1 sg4 0.02201f
C966 sg8 bsn 0.01988f
C967 hsn rb8 0.02022f
C968 b8 sg5 0.06515f
C969 d9 bsn 0.01988f
C970 b4 sr1 0.11349f
C971 gb2 d2 0.02128f
C972 rb5 gn2 0.01437f
C973 ain nr2 0
C974 sr5 sr6 36.75546f
C975 sg1 sg6 0.0586f
C976 b5 sg4 0.07214f
C977 rv328_adcfe_p2_0/gf180mcu_fd_sc_mcu9t5v0__nand3_1_20/a_271_69# gn6 0.00232f
C978 gb0 hsgs 0
C979 sr4 d0 0.04146f
C980 b3 sg4 0
C981 hs nr9 1.35371f
C982 a d8 0.04927f
C983 azn sg1 0.05702f
C984 d3 d2 8.62574f
C985 sg8 nr9 0.0074f
C986 sr8 sg5 0.0959f
C987 rb3 sr6 0.05268f
C988 db4 sr6 0.0229f
C989 sg7 bsn 0.01988f
C990 d4 rb6 0.01739f
C991 rv328_adcfe_p2_0/gf180mcu_fd_sc_mcu9t5v0__nand3_1_19/a_271_69# gn7 0.00232f
C992 d9 nr9 1.5155f
C993 hs hsg 21.19507f
C994 rb4 avdd 5.32566f
C995 q2 rb5 0.04181f
C996 gn3 hsg 4.71103f
C997 d7 avdd 3.32988f
C998 d1 hsg 0.05166f
C999 hsb d5 0.01895f
C1000 rv328_adcfe_p2_0/gf180mcu_fd_sc_mcu9t5v0__nand3_1_8/a_455_69# nr1 0
C1001 sg8 hsg 0.28287f
C1002 hs db5 0.84022f
C1003 rb5 gn1 0.01437f
C1004 hsgs sr8 0
C1005 sr9 nr6 0.03424f
C1006 d9 hsg 0.17503f
C1007 sg3 d5 0.02043f
C1008 sr5 az 0.0259f
C1009 db1 d5 0.02505f
C1010 d8 d0 0.03991f
C1011 gn5 hs 0.0149f
C1012 sr2 ts 0.0208f
C1013 sg8 db5 0.0411f
C1014 rv328_adcfe_p2_0/gf180mcu_fd_sc_mcu9t5v0__nand3_1_8/a_271_69# hsg 0.00297f
C1015 hsn hs 3.53806f
C1016 d9 db5 0.04468f
C1017 hsg b9 0.05764f
C1018 gn5 sg8 0.01656f
C1019 hsn d1 0.02022f
C1020 sr7 sg5 0.05531f
C1021 gn2 sr6 0.01988f
C1022 db2 sg5 0.0229f
C1023 rv328_adcfe_p2_0/gf180mcu_fd_sc_mcu9t5v0__nand3_1_19/a_271_69# db7 0.00139f
C1024 rb3 az 0.02582f
C1025 gn5 d9 0.01437f
C1026 hsn sg8 0.02022f
C1027 xcmp_x xcmp_vbi 0.10441f
C1028 sg4 rb4 0.11051f
C1029 sg7 hsg 0.44198f
C1030 rb1 sr4 0.09927f
C1031 db3 sg9 0.03027f
C1032 rb7 sg2 0.05449f
C1033 sg0 rb9 4.85514f
C1034 sr0 sr2 0.11032f
C1035 sg2 bsb 0.20093f
C1036 sg4 d7 0.02043f
C1037 hsn d9 0.02022f
C1038 nr5 bsb 0.00393f
C1039 nr5 rb7 0.01437f
C1040 rv328_adcfe_p2_0/gf180mcu_fd_sc_mcu9t5v0__nand3_1_18/a_455_69# hs 0
C1041 ts vcm 3.67708f
C1042 sg7 db5 0.0411f
C1043 hsgs sr7 0
C1044 sg9 gb6 0.03104f
C1045 azn rv328_adcfe_p2_0/gf180mcu_fd_sc_mcu9t5v0__nand3_1_12/a_455_69# 0
C1046 a dn 0.33601f
C1047 sr5 gn0 0.01988f
C1048 q2 sr6 0.03437f
C1049 sg5 rb8 0.10382f
C1050 gn5 sg7 0.01656f
C1051 bsn sg6 0.01988f
C1052 rb5 avdd 3.97746f
C1053 hsn sg7 0.02022f
C1054 rb0 b2 0.13497f
C1055 sr6 gn1 0.01988f
C1056 b7 sr0 0.15648f
C1057 azn bsn 0.01029f
C1058 rb7 sg1 0.05491f
C1059 sg1 bsb 0.18976f
C1060 vrefp sr0 0.93395f
C1061 sg0 d4 0.02043f
C1062 rb1 d8 0.01936f
C1063 nr3 sr4 0.01899f
C1064 sr8 nr2 0.01899f
C1065 sr1 sr9 0.04215f
C1066 sample sr1 0.01746f
C1067 gn4 rb9 0.02296f
C1068 gn0 rb3 0.01437f
C1069 bs rb2 0.16555f
C1070 rv328_adcfe_p2_0/gf180mcu_fd_sc_mcu9t5v0__nand3_1_16/a_455_69# hsg 0
C1071 hsg gb7 0.06144f
C1072 b6 rb2 0.13699f
C1073 rb4 d5 0.028f
C1074 d5 d7 0.01733f
C1075 q1 hs 0.35812f
C1076 rb5 sg4 0.06418f
C1077 ain rb2 0.62306f
C1078 gb2 gb1 0.64032f
C1079 rb9 gb9 0.07123f
C1080 q2 az 0.02582f
C1081 rb0 db0 0.0353f
C1082 hsg sg6 0.21846f
C1083 sg9 ab 0.03727f
C1084 rv328_adcfe_p1_0/res1k_l60_n20_w1_0/a_n128_900# rv328_adcfe_p1_0/res1k_l60_n20_w1_0/a_n128_1500# 0.04819f
C1085 rv328_adcfe_p2_0/gf180mcu_fd_sc_mcu9t5v0__nand3_1_17/a_455_69# avdd 0
C1086 a sr1 0.04924f
C1087 vrefp nr8 0.00416f
C1088 sg6 db5 0.0503f
C1089 gn4 d4 0
C1090 hs sg5 0.2139f
C1091 nr2 db2 0.14308f
C1092 sr2 d2 0.02537f
C1093 sr7 nr2 0.01899f
C1094 sample sr9 0.01739f
C1095 sg0 rb6 1.45426f
C1096 azn hsg 0.05702f
C1097 nr3 d8 0.01437f
C1098 bs d3 0.02006f
C1099 sr6 avdd 2.01566f
C1100 gn3 sg5 0.01988f
C1101 hsb sg2 0.02458f
C1102 xcmp_x en 0.1365f
C1103 gn5 sg6 0.02149f
C1104 sg3 sg2 38.06904f
C1105 d1 sg5 0.0189f
C1106 azb ab 0
C1107 rv328_adcfe_p2_0/gf180mcu_fd_sc_mcu9t5v0__nand3_1_7/a_455_69# avdd 0
C1108 sg8 sg5 0.11261f
C1109 db1 sg2 0.02201f
C1110 xcmp_azn avdd 0.8623f
C1111 hsn sg6 0.02022f
C1112 rv328_adcfe_p2_0/gf180mcu_fd_sc_mcu9t5v0__nand3_1_18/a_271_69# hs 0.00297f
C1113 d9 sg5 0.01956f
C1114 hsgs hs 0.04155f
C1115 b4 rb1 0.12157f
C1116 ain d3 0
C1117 rb9 rv328_adcfe_p2_0/gf180mcu_fd_sc_mcu9t5v0__nand3_1_1/a_271_69# 0.00292f
C1118 azn rv328_adcfe_p2_0/gf180mcu_fd_sc_mcu9t5v0__nand3_1_12/a_271_69# 0
C1119 b5 sg2 0.07214f
C1120 nr1 db0 0
C1121 sr1 d0 0.04146f
C1122 nr2 rb8 0.01437f
C1123 b3 sg2 0.0748f
C1124 azc xcmp_o2 0.14058f
C1125 a sample 0.03016f
C1126 sg5 b9 0.04122f
C1127 a sr9 0.05734f
C1128 gn8 avdd 4.31207f
C1129 rb5 d5 0.03713f
C1130 bsn bsb 0.0985f
C1131 sg4 sr6 0.05677f
C1132 sg7 sg5 0.08131f
C1133 hsb sg1 0.02458f
C1134 gn4 rb6 0.01437f
C1135 rb7 bsn 0.01988f
C1136 az avdd 0.55241f
C1137 sg3 sg1 0.11195f
C1138 db1 sg1 0.75432f
C1139 rv328_adcfe_p2_0/gf180mcu_fd_sc_mcu9t5v0__nand3_1_16/a_271_69# hsg 0.00297f
C1140 xcmp_o2 xcmp_azd 0.21158f
C1141 rv328_adcfe_p2_0/gf180mcu_fd_sc_mcu9t5v0__nand3_1_20/a_455_69# gn6 0.01168f
C1142 sr3 d6 0.03176f
C1143 b8 rb2 0.07424f
C1144 b5 sg1 0.07214f
C1145 ain gb5 0
C1146 b3 sg1 0.0748f
C1147 gb3 rb3 0.02941f
C1148 gb3 db4 0.19202f
C1149 sr5 rb9 0.02793f
C1150 sr9 d0 0.06115f
C1151 nr9 bsb 0.03419f
C1152 rv328_adcfe_p2_0/gf180mcu_fd_sc_mcu9t5v0__nand3_1_17/a_271_69# avdd 0.00109f
C1153 ts0 d6 0.01899f
C1154 sg4 az 0.02582f
C1155 xcmp_azn xcmp_tail2 0
C1156 hsg bsb 0.30638f
C1157 vbp b4 0
C1158 rb1 sr1 2.82574f
C1159 hs nr2 2.0853f
C1160 rb7 hsg 2.79587f
C1161 rb2 sr8 0.09335f
C1162 sr3 rb0 0.0612f
C1163 sg2 rb4 0.09484f
C1164 rb3 rb9 0.06826f
C1165 rb9 db4 0.03452f
C1166 gn0 avdd 0.70346f
C1167 sg2 d7 0.02043f
C1168 nr5 rb4 0
C1169 sr6 d5 0.01988f
C1170 nr5 d7 0.02043f
C1171 db5 bsb 0.00104f
C1172 a d0 0.04949f
C1173 azn q1 0
C1174 sr3 q3 0.04545f
C1175 sg8 nr2 0.01437f
C1176 rb7 db5 0.04414f
C1177 nr0 d6 0.01739f
C1178 rv328_adcfe_p2_0/gf180mcu_fd_sc_mcu9t5v0__nand3_1_3/a_271_69# gb9 0.00292f
C1179 d9 nr2 0.01437f
C1180 gb3 gn2 0.01294f
C1181 rv328_adcfe_p1_0/res1k_l60_n20_w1_0/a_n128_2100# rv328_adcfe_p1_0/res1k_l60_n20_w1_0/a_n128_2700# 0.04819f
C1182 rv328_adcfe_p2_0/gf180mcu_fd_sc_mcu9t5v0__nand3_1_12/a_455_69# hsb 0
C1183 sr5 d4 0.01739f
C1184 gn5 bsb 0.00129f
C1185 sg5 sg6 36.98338f
C1186 gn5 rb7 0.01656f
C1187 rb0 ts0 0.01899f
C1188 hsg db8 0.10603f
C1189 dum vcm 10.54303f
C1190 hsn bsb 0.63162f
C1191 hsn rb7 0.02022f
C1192 sr4 b2 0.04124f
C1193 cmp xcmp_o2 0.09121f
C1194 tsb sr2 0
C1195 xcmp_azn xcmp_vb 1.10548f
C1196 rb4 sg1 0.09519f
C1197 azn sg5 0.05702f
C1198 sg1 d7 0.02043f
C1199 rb2 db2 0.06611f
C1200 hsb bsn 2.82725f
C1201 d4 db4 1.26212f
C1202 rb0 nr0 0.11032f
C1203 rb3 d4 0.02787f
C1204 d3 sr8 0.01739f
C1205 sr7 rb2 0.05268f
C1206 rb1 sr9 0.06655f
C1207 sr3 nr1 0.01899f
C1208 sg9 nr4 0.02247f
C1209 sg7 nr2 0.01437f
C1210 gn0 sg4 0.01988f
C1211 gn2 rb9 0.02174f
C1212 rb1 sample 0
C1213 bs sr2 0.22517f
C1214 sg3 bsn 0.01988f
C1215 d5 az 0.02582f
C1216 ab ts 0
C1217 b6 sr2 0.13651f
C1218 nr0 q3 0.00752f
C1219 xcmp_enb xcmp_oc 3.26311f
C1220 azn hsgs 0.83929f
C1221 xds_n2 q2 0.12069f
C1222 tsb vcm 0.04251f
C1223 gb2 db2 0.99016f
C1224 rb5 sg2 0.05517f
C1225 sr5 rb6 0.06148f
C1226 ain sr2 0.37705f
C1227 xcmp_oc xcmp_o1 0.93184f
C1228 sr0 ab 0.03727f
C1229 rb2 rb8 0.05331f
C1230 q2 rb9 0.03442f
C1231 nr5 rb5 0.05248f
C1232 a rb1 0.04924f
C1233 xds_n1 az 0
C1234 bs b7 6.65504f
C1235 rb9 gn1 0.02055f
C1236 vrefp gn7 0.00209f
C1237 bs vrefp 0.81608f
C1238 gb8 nr9 0
C1239 d3 db2 0.02691f
C1240 sr8 gb5 0.01843f
C1241 nr3 sr9 0.029f
C1242 d3 sr7 0.01739f
C1243 rb3 rb6 0.09646f
C1244 db4 rb6 0.02594f
C1245 gn2 d4 0.02022f
C1246 vcb avdd 0
C1247 db9 nr9 0.08064f
C1248 hsb hsg 0.02357f
C1249 b6 b7 43.3528f
C1250 nr7 avdd 2.23433f
C1251 sg3 hsg 0.2222f
C1252 b6 vrefp 3.97944f
C1253 gn0 d5 0.01988f
C1254 db1 hsg 0.1344f
C1255 b0 rb6 0.03537f
C1256 en xcmp_vbi 1.08526f
C1257 b7 ain 23.55613f
C1258 gb8 hsg 0.02957f
C1259 rb5 sg1 0.05577f
C1260 ain vrefp 3.72762f
C1261 db9 hsg 0.11226f
C1262 b1 rb6 0.03499f
C1263 b5 hsg 0.07326f
C1264 rv328_adcfe_p1_0/res1k_l60_n20_w1_0/a_12000_2400# rv328_adcfe_p1_0/res1k_l60_n20_w1_0/a_12000_3000# 0.04819f
C1265 azc q1 0.24872f
C1266 q2 d4 0.02245f
C1267 gb3 avdd 0.54044f
C1268 nr2 sg6 0.01437f
C1269 d3 rb8 0.01739f
C1270 rb1 d0 0.03677f
C1271 b3 hsg 0.07532f
C1272 rv328_adcfe_p2_0/gf180mcu_fd_sc_mcu9t5v0__nand3_1_12/a_271_69# hsb 0.00297f
C1273 hsn hsb 0.05104f
C1274 xds_n2 avdd 2.16759f
C1275 hsn sg3 0.02022f
C1276 d4 gn1 0.01899f
C1277 sg5 bsb 0.26732f
C1278 sr7 gb5 0.01843f
C1279 sg2 sr6 0.05627f
C1280 rb7 sg5 0.05399f
C1281 gn2 rb6 0.01437f
C1282 rb4 bsn 0.01988f
C1283 bsn d7 0.01988f
C1284 xcmp_x avdd 2.67789f
C1285 hs rb2 0.14583f
C1286 b4 b2 0.14522f
C1287 rb9 avdd 27.09048f
C1288 nr5 sr6 0.01437f
C1289 d1 rb2 0.01898f
C1290 gn9 bsb 0.03558f
C1291 sg8 rb2 0.10163f
C1292 hsgs bsb 0.03229f
C1293 sg9 d6 0.02655f
C1294 b8 sr2 0.06515f
C1295 d9 rb2 0.01871f
C1296 vrefp gn6 0
C1297 gb2 hs 1.17736f
C1298 ts top 0.32034f
C1299 sr5 sg0 0.06454f
C1300 d2 ab 0.03729f
C1301 gb5 rb8 0.01437f
C1302 q2 rb6 0.04089f
C1303 rb2 b9 0.04026f
C1304 rv328_adcfe_p2_0/gf180mcu_fd_sc_mcu9t5v0__nand3_1_3/a_455_69# avdd 0
C1305 sr6 sg1 0.05619f
C1306 rb6 gn1 0.01437f
C1307 azb d6 0.02647f
C1308 sg2 az 0.02582f
C1309 hs d3 1.50474f
C1310 sg0 rb3 0.31443f
C1311 rb4 hsg 2.75854f
C1312 sr3 sr4 38.3793f
C1313 sr8 sr2 0.07462f
C1314 sg4 rb9 0.27969f
C1315 sg7 rb2 0.05268f
C1316 sg9 rb0 0.06374f
C1317 rv328_adcfe_p2_0/gf180mcu_fd_sc_mcu9t5v0__nand3_1_13/a_271_69# gb5 0.00292f
C1318 d4 avdd 0.74663f
C1319 hsg d7 0.09011f
C1320 gn3 d3 0
C1321 d1 d3 0.02435f
C1322 b7 b8 38.79727f
C1323 bx rb0 0.11702f
C1324 sg8 d3 0.01739f
C1325 b8 vrefp 13.56693f
C1326 xcmp_ym xcmp_a 0
C1327 rb4 db5 0
C1328 sg9 q3 0.04545f
C1329 b0 sg0 1.09036f
C1330 db5 d7 0.04468f
C1331 xcmp_b top 3.75641f
C1332 d9 d3 0.02122f
C1333 rb5 bsn 0.01988f
C1334 sr5 gn4 0.02857f
C1335 vt ts 0.93943f
C1336 vbp xcmp_a 0.10962f
C1337 azb rb0 0.02642f
C1338 sr4 ts0 0.01437f
C1339 gn5 d7 0.01437f
C1340 b1 sg0 0.12079f
C1341 xcmp_x xcmp_tail2 3.00147f
C1342 vbp xcmp_d1 0.18487f
C1343 hsn rb4 0.02022f
C1344 sr1 b2 0.14929f
C1345 hsn d7 0.02022f
C1346 sg1 az 0.02582f
C1347 b7 sr8 0.04127f
C1348 vrefp sr8 8.53684f
C1349 nr2 bsb 0.0014f
C1350 sg7 d3 0.01739f
C1351 gn0 sg2 0.01988f
C1352 hs gb5 0.88046f
C1353 gn4 db4 1.9966f
C1354 sr2 db2 0.03918f
C1355 sg4 d4 0.0261f
C1356 sr7 sr2 0.0344f
C1357 nr0 sr4 0.0229f
C1358 sg9 nr1 0.01841f
C1359 hsb sg5 0.02458f
C1360 rb7 nr2 0.01437f
C1361 sr3 d8 0.03176f
C1362 rb6 avdd 5.38719f
C1363 rv328_adcfe_p1_0/res1k_l60_n20_w1_0/a_n128_2700# dn 0.0381f
C1364 sg3 sg5 0.11261f
C1365 db1 sg5 0.02201f
C1366 sg8 gb5 0.01843f
C1367 rb9 d5 0.02331f
C1368 d9 gb5 0.01437f
C1369 hsgs hsb 3.7305f
C1370 xcmp_x xcmp_vb 0.34955f
C1371 rb5 hsg 1.19145f
C1372 ain db3 0
C1373 b5 sg5 1.63821f
C1374 b3 sg5 0.04773f
C1375 d8 ts0 0.01899f
C1376 xds_n2 xds_n1 0
C1377 xcmp_o2 xcmp_azn 0.42509f
C1378 rb2 sg6 0.05268f
C1379 sr2 rb8 0.11974f
C1380 q2 sg0 0.03441f
C1381 rv328_adcfe_p2_0/gf180mcu_fd_sc_mcu9t5v0__nand3_1_18/a_271_69# gb8 0.00292f
C1382 rb5 db5 0.06803f
C1383 db9 gn9 7.14564f
C1384 ain gb6 0
C1385 b7 sr7 2.83112f
C1386 rv328_adcfe_p2_0/gf180mcu_fd_sc_mcu9t5v0__nand3_1_3/a_271_69# avdd 0
C1387 bsn sr6 0.01988f
C1388 gn0 sg1 0.01988f
C1389 vrefp sr7 6.54468f
C1390 nr0 d8 0.01739f
C1391 sg7 gb5 0.01843f
C1392 sg4 rb6 0.05563f
C1393 azn rb2 0.05702f
C1394 rv328_adcfe_p2_0/gf180mcu_fd_sc_mcu9t5v0__nand3_1_19/a_271_69# rb7 0.00292f
C1395 gn5 rb5 1.98265f
C1396 rv328_adcfe_p1_0/res1k_l60_n20_w1_0/a_n128_300# rv328_adcfe_p1_0/res1k_l60_n20_w1_0/a_n128_900# 0.04819f
C1397 rb5 hsn 0.02022f
C1398 d4 d5 11.3259f
C1399 db7 gb6 0.01745f
C1400 tsb ab 0
C1401 b4 sr3 0.12828f
C1402 xcmp_y xcmp_b 2.13532f
C1403 b7 rb8 0
C1404 hs rv328_adcfe_p2_0/gf180mcu_fd_sc_mcu9t5v0__nand3_1_4/a_455_69# 0
C1405 vrefp rb8 9.24707f
C1406 b0 en 0
C1407 sr9 db0 0.09363f
C1408 d3 sg6 0.01739f
C1409 bs ab 0.08012f
C1410 rv328_adcfe_p2_0/gf180mcu_fd_sc_mcu9t5v0__nand3_1_14/a_271_69# rb4 0.00292f
C1411 en b1 0
C1412 bsn az 0.00262f
C1413 azn d3 0.06266f
C1414 gn6 gb6 0.09446f
C1415 hsg sr6 0.19781f
C1416 rb4 sg5 0.11595f
C1417 ts d6 0.02057f
C1418 sg5 d7 0.01956f
C1419 hs sr2 0.16011f
C1420 sg0 avdd 1.18747f
C1421 ain ab 0
C1422 sg3 nr2 0.01437f
C1423 xcmp_vbi avdd 32.70388f
C1424 db1 nr2 0
C1425 d1 sr2 0.0189f
C1426 sr6 db5 0.05009f
C1427 rb6 d5 0.01445f
C1428 gn8 nr9 0.00971f
C1429 sg8 sr2 0.07741f
C1430 sr0 d6 0.0348f
C1431 d9 sr2 0.03176f
C1432 gn5 sr6 0.02558f
C1433 gb3 sg2 0.02445f
C1434 sr5 db4 0.0229f
C1435 sr5 rb3 0.05268f
C1436 gb5 sg6 0.02762f
C1437 hsn sr6 0.02026f
C1438 rb0 ts 0.02057f
C1439 hsg gn8 1.42324f
C1440 sr2 b9 0.04178f
C1441 dum top 40.37025f
C1442 vrefp hs 0
C1443 hsg az 0.02582f
C1444 rb2 bsb 0.20367f
C1445 rb0 sr0 2.17326f
C1446 rb3 db4 0
C1447 sg9 sr4 0.35088f
C1448 db3 sr8 0.0229f
C1449 sg2 rb9 0.43151f
C1450 sg7 sr2 0.10632f
C1451 sr3 sr1 0.04785f
C1452 sg0 sg4 0.06829f
C1453 rb7 rb2 0.09138f
C1454 gn4 avdd 0.91024f
C1455 xcmp_n1 xcmp_b 0.12701f
C1456 b7 sg8 0.07597f
C1457 d0 db0 2.70649f
C1458 nr5 rb9 0.02331f
C1459 vrefp sg8 0.46581f
C1460 bx sr4 0.04273f
C1461 azc xcmp_oc 0.11107f
C1462 sr0 q3 0.04545f
C1463 b0 rb3 0.03373f
C1464 vrefp d9 0
C1465 sr8 gb6 0.02211f
C1466 rb5 sg5 0.09572f
C1467 sr5 gn2 0.01988f
C1468 azb sr4 0.02642f
C1469 b7 b9 0.24685f
C1470 hs rv328_adcfe_p2_0/gf180mcu_fd_sc_mcu9t5v0__nand3_1_4/a_271_69# 0.00297f
C1471 sr1 ts0 0.01437f
C1472 b1 rb3 0.03364f
C1473 vrefp b9 27.62616f
C1474 gb9 avdd 5.05071f
C1475 rb1 b2 0.4723f
C1476 xcmp_azd xcmp_oc 2.15804f
C1477 b7 sg7 2.74129f
C1478 xcmp_vbi xcmp_tail2 2.59499f
C1479 vt dum 0
C1480 rb9 sg1 0.52911f
C1481 vrefp sg7 0.27312f
C1482 d3 bsb 0.02457f
C1483 sg2 d4 0.02043f
C1484 b0 b1 53.85916f
C1485 gn0 hsg 4.70862f
C1486 gn4 sg4 2.91884f
C1487 db3 db2 0
C1488 sr0 nr1 0
C1489 sr3 sr9 0.04244f
C1490 db3 sr7 0.0229f
C1491 sample sr3 0.01744f
C1492 sg9 d8 0.06789f
C1493 nr0 sr1 0.0229f
C1494 d3 rb7 0.01739f
C1495 rb3 gn2 0.02247f
C1496 rb4 nr2 0.01437f
C1497 nr2 d7 0.01437f
C1498 q2 sr5 0.03437f
C1499 rv328_adcfe_p1_0/res1k_l60_n20_w1_0/a_12000_0# rv328_adcfe_p1_0/res1k_l60_n20_w1_0/a_12000_600# 0.04819f
C1500 rv328_adcfe_p2_0/gf180mcu_fd_sc_mcu9t5v0__nand3_1_9/a_455_69# nr1 0.01168f
C1501 sg0 d5 0.02043f
C1502 en avdd 2.41873f
C1503 d2 d6 0.02173f
C1504 sr7 gb6 0.02215f
C1505 sr5 gn1 0.01988f
C1506 azb d8 0.02645f
C1507 sample ts0 4.20925f
C1508 rv328_adcfe_p2_0/gf180mcu_fd_sc_mcu9t5v0__nand3_1_1/a_271_69# avdd 0
C1509 sr9 ts0 0.01437f
C1510 db3 rb8 0.02594f
C1511 tsb vt 0.84588f
C1512 sr8 ab 0.03727f
C1513 sr2 sg6 0.10531f
C1514 q2 rb3 0.04498f
C1515 xcmp_vbi xcmp_vb 2.83261f
C1516 a sr3 0.04924f
C1517 rb3 gn1 0.01437f
C1518 d4 sg1 0.02043f
C1519 sr6 sg5 0.06686f
C1520 gb5 bsb 0
C1521 vrefp gb7 0
C1522 db6 db7 0
C1523 xcmp_y dum 0.08948f
C1524 nr0 sr9 0.03261f
C1525 azn sr2 0.05702f
C1526 sg2 rb6 0.05577f
C1527 rb7 gb5 0.01437f
C1528 rb0 d2 0.02001f
C1529 rb8 gb6 0.02211f
C1530 hsb rb2 0.02458f
C1531 sg3 rb2 0.10711f
C1532 nr5 rb6 0.01437f
C1533 db1 rb2 0.02505f
C1534 d2 q3 0.0509f
C1535 gn4 d5 0.04792f
C1536 hsgs sr6 0
C1537 vbp b2 0
C1538 a ts0 0.01915f
C1539 rv328_adcfe_p2_0/gf180mcu_fd_sc_mcu9t5v0__nand3_1_11/a_455_69# rb0 0
C1540 d1b ts 0.0419f
C1541 b4 sg9 0.00327f
C1542 cmp xcmp_oc 0.09313f
C1543 sg9 nr6 0.03402f
C1544 ain nr4 0
C1545 rb5 nr2 0.01437f
C1546 b7 sg6 0.14416f
C1547 vrefp sg6 0.33839f
C1548 b5 rb2 0.07214f
C1549 sr5 avdd 1.38744f
C1550 db6 gn6 1.60142f
C1551 sr3 d0 0.04146f
C1552 sr7 ab 0.03727f
C1553 b3 rb2 0.08597f
C1554 b4 bx 0.19918f
C1555 gb2 db1 0.00252f
C1556 rb6 sg1 0.05686f
C1557 sg5 az 0.02582f
C1558 nr1 d2 0.01439f
C1559 rb9 bsn 0.02392f
C1560 en xcmp_tail2 0
C1561 hsb d3 0.01895f
C1562 hs db3 0.73038f
C1563 rb3 avdd 5.6583f
C1564 db4 avdd 0.44761f
C1565 hsg nr7 0.03621f
C1566 gn3 db3 2.19412f
C1567 sg3 d3 0.02553f
C1568 d0 ts0 0.01906f
C1569 db1 d3 0.02505f
C1570 rb8 ab 0.03727f
C1571 rv328_adcfe_p2_0/gf180mcu_fd_sc_mcu9t5v0__nand3_1_9/a_271_69# nr1 0.00232f
C1572 hsgs az 0.02445f
C1573 sg8 db3 0.0229f
C1574 azb dn 0.44286f
C1575 hs gb6 0.75782f
C1576 d9 db3 0.02685f
C1577 xcmp_vbi xcmp_tail 6.75673f
C1578 b0 avdd 1.10018f
C1579 gb3 hsg 0.02728f
C1580 sr5 sg4 0.06624f
C1581 nr0 d0 3.96999f
C1582 rb9 nr9 0.08271f
C1583 xcmp_n1 dum 0.04962f
C1584 sr4 ts 0.02099f
C1585 sg8 gb6 0.02211f
C1586 b1 avdd 1.90289f
C1587 d9 gb6 0.02039f
C1588 en xcmp_vb 11.75739f
C1589 d4 bsn 0.01988f
C1590 nr2 sr6 0.01899f
C1591 gn0 sg5 0.01988f
C1592 sr2 bsb 0.25247f
C1593 hsg rb9 1.73868f
C1594 sg4 db4 0.56731f
C1595 rb1 sr3 0.05654f
C1596 rb3 sg4 0.05279f
C1597 sg7 db3 0.0229f
C1598 sg9 sr1 0.78719f
C1599 sg0 sg2 0.07811f
C1600 sr0 sr4 0.09626f
C1601 rb4 rb2 0.06625f
C1602 rb7 sr2 0.07012f
C1603 gn2 avdd 0.91026f
C1604 rb2 d7 0.01849f
C1605 rv328_adcfe_p2_0/gf180mcu_fd_sc_mcu9t5v0__nand3_1_7/a_455_69# nr2 0.01168f
C1606 bx sr1 0.04783f
C1607 rv328_adcfe_p2_0/gf180mcu_fd_sc_mcu9t5v0__nand3_1_3/a_455_69# nr9 0.01168f
C1608 rb9 db5 0.06227f
C1609 sg7 gb6 0.02211f
C1610 bs d6 0.01968f
C1611 gn5 rb9 0.02564f
C1612 azb sr1 0.02642f
C1613 d8 ts 0.02057f
C1614 rb1 ts0 0.01899f
C1615 hs ab 0.17653f
C1616 hsn rb9 0.02426f
C1617 q2 avdd 2.51417f
C1618 sr5 d5 1.74508f
C1619 d1 ab 0.03729f
C1620 b7 rb7 5.10594f
C1621 b7 bsb 7.03362f
C1622 ain d6 0
C1623 azc vcm 0.01426f
C1624 sg0 sg1 38.91742f
C1625 bsn rb6 0.01988f
C1626 vrefp bsb 1.37277f
C1627 vrefp rb7 4.57805f
C1628 sg8 ab 0.03727f
C1629 gn1 avdd 0.69343f
C1630 sr0 d8 0.0348f
C1631 sg9 sr9 14.10152f
C1632 nr3 sr3 2.83093f
C1633 hsg d4 0.05916f
C1634 nr4 sr8 0.01899f
C1635 sg4 gn2 0.01988f
C1636 sample sg9 0.01749f
C1637 d3 rb4 0.01747f
C1638 rb1 nr0 0.01739f
C1639 bs rb0 0.26359f
C1640 rv328_adcfe_p2_0/gf180mcu_fd_sc_mcu9t5v0__nand3_1_16/a_455_69# db3 0.00394f
C1641 d9 ab 0.03727f
C1642 d3 d7 0.02173f
C1643 gb1 rb0 0
C1644 nr5 gn4 0.01188f
C1645 b6 rb0 0.13755f
C1646 rb3 d5 0.01833f
C1647 db4 d5 0.02691f
C1648 gb7 gb6 0
C1649 rv328_adcfe_p1_0/res1k_l60_n20_w1_0/a_n128_4500# rv328_adcfe_p1_0/res1k_l60_n20_w1_0/a_n128_5100# 0.04819f
C1650 xcmp_o1 top 0.04929f
C1651 ain rb0 0.37255f
C1652 rb5 rb2 0.09912f
C1653 azb sr9 0.02642f
C1654 azb sample 0.02642f
C1655 vrefp db8 0
C1656 q2 sg4 0.03437f
C1657 db3 sg6 0.0229f
C1658 sg7 ab 0.03727f
C1659 hsn d4 0.02022f
C1660 a sg9 0.04924f
C1661 ain q3 0.00223f
C1662 sg4 gn1 0.01988f
C1663 hsg rb6 2.71544f
C1664 nr8 d8 1.11397f
C1665 rb4 gb5 0
C1666 sr7 nr4 0.01899f
C1667 sr4 d2 0.01739f
C1668 sg6 gb6 1.49923f
C1669 gn6 d6 0
C1670 gb5 d7 0.01437f
C1671 hsb sr2 0.02461f
C1672 gb1 nr1 0.36368f
C1673 xds_n2 q1 0.17911f
C1674 sg3 sr2 0.07092f
C1675 gn2 d5 0.02022f
C1676 db1 sr2 0.02201f
C1677 rb6 db5 0.05333f
C1678 azb a 10.49838f
C1679 dn ts 5.61728f
C1680 b4 sr0 0.14516f
C1681 rv328_adcfe_p2_0/gf180mcu_fd_sc_mcu9t5v0__nand3_1_3/a_271_69# nr9 0.00232f
C1682 ain nr1 0
C1683 rb5 d3 0.01739f
C1684 xcmp_o2 xcmp_vbi 3.34819f
C1685 xcmp_o3 vbp 0.10668f
C1686 gn5 rb6 0.02576f
C1687 b5 sr2 0.07806f
C1688 sg9 d0 0.03672f
C1689 nr4 rb8 0.01437f
C1690 b3 sr2 0.09121f
C1691 hsn rb6 0.02022f
C1692 q2 d5 0.0225f
C1693 d8 d2 0.02122f
C1694 rb2 sr6 0.05268f
C1695 rb9 sg5 0.2608f
C1696 sg0 bsn 0.02392f
C1697 b7 sg3 0.13562f
C1698 vrefp sg3 0.3402f
C1699 sg4 avdd 1.02622f
C1700 gb2 rv328_adcfe_p2_0/gf180mcu_fd_sc_mcu9t5v0__nand3_1_17/a_455_69# 0
C1701 rv328_adcfe_p2_0/gf180mcu_fd_sc_mcu9t5v0__nand3_1_16/a_271_69# db3 0.00139f
C1702 gn1 d5 0.01899f
C1703 azb d0 0.02683f
C1704 vrefp gb8 0
C1705 gb0 rb0 0.03196f
C1706 sg6 ab 0.03727f
C1707 xcmp_azn xcmp_oc 0.07525f
C1708 rb9 gn9 0.23332f
C1709 vrefp db9 0
C1710 b8 rb0 0.08053f
C1711 sr8 d6 0.01761f
C1712 b7 b5 0.16855f
C1713 rb5 gb5 0.02813f
C1714 b7 b3 0.10876f
C1715 b5 vrefp 2.38688f
C1716 xds_n1 q2 0.13096f
C1717 xcmp_y xcmp_o1 2.13474f
C1718 vrefp b3 1.3647f
C1719 sr5 sg2 0.05628f
C1720 azn ab 1.24908f
C1721 rv328_adcfe_p2_0/gf180mcu_fd_sc_mcu9t5v0__nand3_1_17/a_455_69# d3 0.00394f
C1722 sr1 ts 0.02075f
C1723 nr5 sr5 0.84835f
C1724 xcmp_tail2 avdd 4.95247f
C1725 rv328_adcfe_p2_0/gf180mcu_fd_sc_mcu9t5v0__nand3_1_10/a_455_69# gn0 0.01168f
C1726 d3 sr6 0.01739f
C1727 d4 sg5 0.01739f
C1728 rb2 az 0.02582f
C1729 db3 bsb 0
C1730 hs nr4 1.69025f
C1731 sg0 hsg 0.18019f
C1732 rb0 sr8 0.10187f
C1733 rb3 sg2 0.06262f
C1734 rb1 sg9 0.05687f
C1735 sr0 sr1 39.30783f
C1736 db3 rb7 0.02594f
C1737 rb4 sr2 0.11025f
C1738 sr2 d7 0.03176f
C1739 gn3 nr4 0.0113f
C1740 nr5 db4 0
C1741 gb0 nr1 0.00142f
C1742 bx rb1 0.02803f
C1743 sr8 q3 0.04545f
C1744 sg8 nr4 0.01437f
C1745 gb6 bsb 0.00131f
C1746 sr7 d6 0.01761f
C1747 rb7 gb6 0.02211f
C1748 db2 d6 0.02685f
C1749 d5 avdd 0.76848f
C1750 hsg rv328_adcfe_p2_0/gf180mcu_fd_sc_mcu9t5v0__nand3_1_1/a_455_69# 0
C1751 d9 nr4 0.01437f
C1752 sr5 sg1 0.05627f
C1753 azb rb1 0.02642f
C1754 sample ts 0.04635f
C1755 xcmp_o2 en 0.49758f
C1756 b1 sg2 0
C1757 sr9 ts 5.21861f
C1758 xcmp_vb avdd 1.48253f
C1759 sr3 b2 0
C1760 hsn sg0 0.02426f
C1761 tsb sr4 0
C1762 b7 rb4 0.13562f
C1763 sr6 gb5 0.02765f
C1764 rb6 sg5 0.06358f
C1765 rb3 sg1 0.05479f
C1766 vrefp rb4 1.12752f
C1767 d3 az 0.02582f
C1768 xds_n1 avdd 3.33158f
C1769 vrefp d7 0
C1770 gn4 hsg 4.71138f
C1771 gn2 sg2 2.74743f
C1772 nr1 sr8 0.01899f
C1773 sr7 rb0 0.0612f
C1774 sg7 nr4 0.01437f
C1775 nr3 sg9 0.02174f
C1776 sr0 sr9 0.04206f
C1777 sample sr0 0.01747f
C1778 rb9 nr2 0.02174f
C1779 gn0 rb2 0.01437f
C1780 bs sr4 0.18639f
C1781 rb8 d6 0.01761f
C1782 db6 gb7 0
C1783 xcmp_n1 xcmp_o1 4.86659f
C1784 gb9 nr9 2.86861f
C1785 gb2 rv328_adcfe_p2_0/gf180mcu_fd_sc_mcu9t5v0__nand3_1_17/a_271_69# 0
C1786 b0 sg1 0
C1787 b6 sr4 0.13651f
C1788 sg4 d5 0.27573f
C1789 gn4 db5 0
C1790 sr7 q3 0.04545f
C1791 a ts 0.10793f
C1792 ain sr4 0.30177f
C1793 rb5 sr2 0.07012f
C1794 b1 sg1 0.2736f
C1795 hsg gb9 0.03329f
C1796 ab bsb 0.16192f
C1797 db6 sg6 0.30451f
C1798 rb0 rb8 0.06005f
C1799 q2 sg2 0.0344f
C1800 rb7 ab 0.03727f
C1801 rv328_adcfe_p2_0/gf180mcu_fd_sc_mcu9t5v0__nand3_1_14/a_455_69# gn4 0.01168f
C1802 rv328_adcfe_p2_0/gf180mcu_fd_sc_mcu9t5v0__nand3_1_17/a_271_69# d3 0.00139f
C1803 a sr0 0.04924f
C1804 sg2 gn1 0.01988f
C1805 rb8 q3 0.04545f
C1806 rv328_adcfe_p2_0/gf180mcu_fd_sc_mcu9t5v0__nand3_1_20/a_271_69# rb6 0.00292f
C1807 gn0 d3 0.01989f
C1808 nr2 d4 0.01437f
C1809 rv328_adcfe_p2_0/gf180mcu_fd_sc_mcu9t5v0__nand3_1_10/a_271_69# gn0 0.00232f
C1810 gn7 d8 0.23974f
C1811 sr1 d2 0.04865f
C1812 nr8 sr9 0.06422f
C1813 sr7 nr1 0.01899f
C1814 bs d8 0.0196f
C1815 rv328_adcfe_p1_0/res1k_l60_n20_w1_0/a_n128_300# avdd 0.00154f
C1816 sg3 db3 0.63023f
C1817 xcmp_xm xcmp_y 0.0078f
C1818 d0 ts 0.02057f
C1819 xcmp_tail2 xcmp_vb 0.06711f
C1820 b7 rb5 0.13562f
C1821 sr6 rv328_adcfe_p2_0/gf180mcu_fd_sc_mcu9t5v0__nand3_1_4/a_455_69# 0
C1822 xcmp_tail avdd 6.24519f
C1823 vrefp rb5 1.32937f
C1824 hs d6 0.14155f
C1825 sr5 bsn 0.01988f
C1826 hsg rv328_adcfe_p2_0/gf180mcu_fd_sc_mcu9t5v0__nand3_1_1/a_271_69# 0.00297f
C1827 q2 sg1 0.0344f
C1828 gn3 d6 0.02022f
C1829 d1 d6 0.022f
C1830 nr0 db0 0.25139f
C1831 sr0 d0 1.87649f
C1832 nr4 sg6 0.01437f
C1833 nr1 rb8 0.01437f
C1834 sg8 d6 0.01761f
C1835 rv328_adcfe_p2_0/gf180mcu_fd_sc_mcu9t5v0__nand3_1_6/a_271_69# db2 0.00139f
C1836 gn1 sg1 2.66133f
C1837 d9 d6 0.0192f
C1838 d8 db7 0
C1839 sr9 d2 0.0274f
C1840 sr2 sr6 0.03737f
C1841 sg0 sg5 0.12101f
C1842 nr2 rb6 0.01437f
C1843 rb3 bsn 0.01988f
C1844 hs rb0 0.10452f
C1845 sg2 avdd 1.04306f
C1846 d1 rb0 0.02892f
C1847 nr5 avdd 1.02059f
C1848 rv328_adcfe_p2_0/gf180mcu_fd_sc_mcu9t5v0__nand3_1_15/a_455_69# hs 0
C1849 hs q3 2.18915f
C1850 sg8 rb0 0.10865f
C1851 sg7 d6 0.01761f
C1852 b8 sr4 0.06515f
C1853 xcmp_a xcmp_b 11.39428f
C1854 bs b4 1.87851f
C1855 d9 rb0 0.02101f
C1856 d1 q3 0.05093f
C1857 gb3 rb2 0
C1858 sr5 hsg 0.20361f
C1859 d8 gn6 0.0258f
C1860 sg8 q3 0.04545f
C1861 rb1 ts 0.02057f
C1862 b6 b4 0.17667f
C1863 a d2 0.04938f
C1864 hsb ab 2.04237f
C1865 rv328_adcfe_p2_0/gf180mcu_fd_sc_mcu9t5v0__nand3_1_1/a_455_69# gn9 0.01169f
C1866 d9 q3 0.05063f
C1867 rb0 b9 0.04628f
C1868 sg3 ab 0.03727f
C1869 b7 sr6 0.16357f
C1870 rv328_adcfe_p2_0/gf180mcu_fd_sc_mcu9t5v0__nand3_1_14/a_271_69# gn4 0.00232f
C1871 vrefp sr6 3.04374f
C1872 sr5 db5 0.08268f
C1873 ain nr6 0
C1874 b4 ain 4.32594f
C1875 gn4 sg5 0.01988f
C1876 sg1 avdd 1.03652f
C1877 sr2 az 0.02587f
C1878 gb2 gb3 0.57909f
C1879 hs nr1 2.67512f
C1880 hsg db4 0.13745f
C1881 rb3 hsg 2.85772f
C1882 sr4 sr8 0.07958f
C1883 sg4 sg2 0.06976f
C1884 sg7 rb0 0.0597f
C1885 rb9 rb2 0.06739f
C1886 db3 rb4 0.02594f
C1887 rb1 sr0 0.12144f
C1888 db3 d7 0.02685f
C1889 gn5 sr5 0.03656f
C1890 rv328_adcfe_p2_0/gf180mcu_fd_sc_mcu9t5v0__nand3_1_9/a_455_69# rb1 0
C1891 d1 nr1 2.48728f
C1892 nr5 sg4 0.00257f
C1893 sr5 hsn 0.02025f
C1894 db4 db5 0
C1895 sg8 nr1 0.01437f
C1896 sg7 q3 0.04545f
C1897 b0 hsg 0.09192f
C1898 d9 nr1 0.01437f
C1899 d7 gb6 0.1344f
C1900 gb3 d3 0.02128f
C1901 d2 d0 0.04173f
C1902 q2 bsn 0.01988f
C1903 vrefp gn8 0
C1904 sr3 ts0 0.01437f
C1905 b1 hsg 0.09413f
C1906 rv328_adcfe_p2_0/gf180mcu_fd_sc_mcu9t5v0__nand3_1_8/a_271_69# nr1 0
C1907 hsn rb3 0.02022f
C1908 rv328_adcfe_p2_0/gf180mcu_fd_sc_mcu9t5v0__nand3_1_14/a_455_69# db4 0.00394f
C1909 tsb sr1 0
C1910 xcmp_tail xcmp_vb 0.00174f
C1911 sg4 sg1 0.06275f
C1912 gn9 gb9 0.61086f
C1913 rv328_adcfe_p2_0/gf180mcu_fd_sc_mcu9t5v0__nand3_1_11/a_455_69# d0 0.00394f
C1914 bx b2 0.21471f
C1915 nr4 bsb 0.0014f
C1916 gn2 hsg 4.71054f
C1917 sr8 d8 1.12119f
C1918 gn6 nr6 0.00248f
C1919 sr7 sr4 0.0432f
C1920 sr4 db2 0.0229f
C1921 gn0 sr2 0.01988f
C1922 sr3 nr0 0.0229f
C1923 sg6 d6 0.02681f
C1924 sg7 nr1 0.01437f
C1925 rb7 nr4 0.01437f
C1926 d3 rb9 0.02549f
C1927 rb2 d4 0.01833f
C1928 bs sr1 0.2263f
C1929 rv328_adcfe_p2_0/gf180mcu_fd_sc_mcu9t5v0__nand3_1_13/a_455_69# gb4 0
C1930 b6 sr1 0.13651f
C1931 sg2 d5 0.02043f
C1932 azn d6 0.05702f
C1933 rv328_adcfe_p2_0/gf180mcu_fd_sc_mcu9t5v0__nand3_1_15/a_271_69# hs 0.00297f
C1934 xcmp_o2 avdd 3.21523f
C1935 rb5 db3 0.02594f
C1936 ain sr1 0.34915f
C1937 nr5 d5 5.22812f
C1938 rv328_adcfe_p2_0/gf180mcu_fd_sc_mcu9t5v0__nand3_1_12/a_455_69# avdd 0
C1939 q2 hsg 5.58651f
C1940 rb0 sg6 0.0597f
C1941 sr4 rb8 0.11974f
C1942 rb4 ab 0.03727f
C1943 ab d7 0.03727f
C1944 tsb sample 0.0274f
C1945 tsb sr9 0.06493f
C1946 d1b hs 0.21733f
C1947 b4 b8 0.17613f
C1948 rv328_adcfe_p2_0/gf180mcu_fd_sc_mcu9t5v0__nand3_1_1/a_271_69# gn9 0.00232f
C1949 xcmp_ym xcmp_b 0
C1950 rb5 gb6 0
C1951 hsg gn1 4.70981f
C1952 sg6 q3 0.04545f
C1953 d8 db2 0.02685f
C1954 rb1 d2 0.02829f
C1955 gn7 sr9 0.05063f
C1956 rb9 gb5 0.02357f
C1957 rb2 rb6 0.09386f
C1958 azn rb0 0.05702f
C1959 sr7 d8 0.03555f
C1960 d3 d4 9.9758f
C1961 bs sr9 0.07483f
C1962 bsn avdd 3.57979f
C1963 vbp xcmp_b 0.12301f
C1964 sg1 d5 0.02043f
C1965 azc xcmp_y 0.11088f
C1966 q2 hsn 0.02079f
C1967 b4 sr8 0.04127f
C1968 sr8 nr6 0.02423f
C1969 sr5 sg5 0.0709f
C1970 a tsb 0.04187f
C1971 ain sr9 0.16242f
C1972 d8 rb8 0.30403f
C1973 nr1 sg6 0.01437f
C1974 nr9 avdd 10.28172f
C1975 bs a 1.85281f
C1976 rv328_adcfe_p2_0/gf180mcu_fd_sc_mcu9t5v0__nand3_1_14/a_271_69# db4 0.00139f
C1977 sr5 hsgs 0
C1978 xcmp_a dum 3.75084f
C1979 db3 sr6 0.0229f
C1980 rb3 sg5 0.09659f
C1981 db4 sg5 0.0229f
C1982 sg4 bsn 0.01988f
C1983 d3 rb6 0.01739f
C1984 hs sr4 0.20279f
C1985 rv328_adcfe_p2_0/gf180mcu_fd_sc_mcu9t5v0__nand3_1_11/a_271_69# d0 0.00139f
C1986 hsg avdd 4.53219f
C1987 rb5 ab 0.03727f
C1988 sg3 nr4 0.00212f
C1989 gn3 sr4 0.02807f
C1990 ain a 0
C1991 d1 sr4 0.0189f
C1992 rv328_adcfe_p2_0/gf180mcu_fd_sc_mcu9t5v0__nand3_1_13/a_271_69# gb4 0
C1993 b0 sg5 0.04828f
C1994 sr6 gb6 0.07144f
C1995 sg8 sr4 0.07856f
C1996 d6 bsb 0.02327f
C1997 db5 avdd 2.12244f
C1998 rv328_adcfe_p2_0/gf180mcu_fd_sc_mcu9t5v0__nand3_1_5/a_455_69# sr5 0
C1999 sr7 nr6 0.03343f
C2000 rb7 d6 0.01769f
C2001 b8 sr1 0.06515f
C2002 d9 sr4 0.03176f
C2003 b1 sg5 0.04813f
C2004 vcb vcm 1.8257f
C2005 sr9 gn6 0.03527f
C2006 bs d0 0.0224f
C2007 gn5 avdd 1.96376f
C2008 rv328_adcfe_p2_0/gf180mcu_fd_sc_mcu9t5v0__nand3_1_12/a_271_69# avdd 0.00109f
C2009 sr4 b9 0.04178f
C2010 hsn avdd 2.45845f
C2011 rv328_adcfe_p2_0/gf180mcu_fd_sc_mcu9t5v0__nand3_1_14/a_455_69# avdd 0
C2012 rv328_adcfe_p2_0/gf180mcu_fd_sc_mcu9t5v0__nand3_1_7/a_271_69# d2 0.00139f
C2013 azc xcmp_n1 0.15462f
C2014 rb6 gb5 0.02364f
C2015 gn2 sg5 0.01988f
C2016 xcmp_o2 xcmp_vb 0.00174f
C2017 q1 q2 2.29331f
C2018 vrefp nr7 0
C2019 rb0 bsb 0.23652f
C2020 hs d8 2.07451f
C2021 sg4 hsg 0.20888f
C2022 sr3 sg9 0.45488f
C2023 sg7 sr4 0.10614f
C2024 sr1 sr8 0.07445f
C2025 sg0 rb2 0.33439f
C2026 rb8 nr6 0.02483f
C2027 rb9 sr2 0.05161f
C2028 rb7 rb0 0.09804f
C2029 db6 d7 0
C2030 gn3 d8 0.02022f
C2031 xcmp_vbi xcmp_oc 0.06079f
C2032 gb4 hs 0.97408f
C2033 bsn d5 0.01988f
C2034 d1 d8 0.0217f
C2035 gb0 sr9 0.02289f
C2036 gb4 gn3 0.01294f
C2037 rv328_adcfe_p2_0/gf180mcu_fd_sc_mcu9t5v0__nand3_1_18/a_455_69# avdd 0
C2038 sg4 db5 1.26499f
C2039 q3 bsb 0.01752f
C2040 sg8 d8 0.06805f
C2041 rb7 q3 0.04545f
C2042 b8 sr9 0.00134f
C2043 d9 d8 18.08199f
C2044 sr5 nr2 0.01899f
C2045 q2 sg5 0.03437f
C2046 sr6 ab 0.03727f
C2047 azb sr3 0.02642f
C2048 sg9 ts0 0.01437f
C2049 hsn sg4 0.02022f
C2050 sr0 b2 0.16023f
C2051 azn d1b 0.00242f
C2052 sg5 gn1 0.01988f
C2053 b7 rb9 0.00346f
C2054 sg2 sg1 38.57032f
C2055 vrefp rb9 17.8644f
C2056 nr1 bsb 0.0014f
C2057 sg0 d3 0.02043f
C2058 sr2 d4 0.03176f
C2059 sg7 d8 0.67655f
C2060 rb4 nr4 0.02423f
C2061 sr1 db2 0
C2062 sr8 sr9 25.04166f
C2063 sample sr8 0.01739f
C2064 sr7 sr1 0.03407f
C2065 sg9 nr0 0.01739f
C2066 rb3 nr2 0.01437f
C2067 rb7 nr1 0.01437f
C2068 bs rb1 0.16832f
C2069 nr4 d7 0.01437f
C2070 gb1 rb1 0.03328f
C2071 azb ts0 0.05197f
C2072 b6 rb1 0.1373f
C2073 hsg d5 0.05803f
C2074 hsb d6 0.01895f
C2075 q1 avdd 4.87782f
C2076 hs nr6 1.37014f
C2077 rb5 db6 0
C2078 ain rb1 0.29684f
C2079 sg3 d6 0.02043f
C2080 d5 db5 1.26597f
C2081 ab az 0.03144f
C2082 vbp dum 0.05154f
C2083 db1 d6 0.02505f
C2084 sr4 sg6 0.10547f
C2085 sr1 rb8 0.11991f
C2086 b4 sg8 0.04895f
C2087 a sr8 0.04924f
C2088 sg8 nr6 0.02483f
C2089 dn hs 0.15368f
C2090 gn5 d5 0
C2091 d9 nr6 0.02034f
C2092 gb0 d0 0.06049f
C2093 rv328_adcfe_p2_0/gf180mcu_fd_sc_mcu9t5v0__nand3_1_14/a_271_69# avdd 0.00109f
C2094 hsn d5 0.02022f
C2095 gn2 nr2 0.0081f
C2096 sr7 sr9 0.1132f
C2097 sr9 db2 0.03291f
C2098 azn sr4 0.05702f
C2099 sample sr7 0.01739f
C2100 sr2 rb6 0.07012f
C2101 sg5 avdd 2.77563f
C2102 d8 gb7 0.36213f
C2103 hsb rb0 0.02458f
C2104 b4 b9 0.0434f
C2105 gb4 rv328_adcfe_p2_0/gf180mcu_fd_sc_mcu9t5v0__nand3_1_16/a_455_69# 0
C2106 sg3 rb0 0.10294f
C2107 db1 rb0 0
C2108 en xcmp_oc 0.16857f
C2109 hsb q3 0.02874f
C2110 rv328_adcfe_p2_0/gf180mcu_fd_sc_mcu9t5v0__nand3_1_18/a_271_69# avdd 0.00109f
C2111 gn9 avdd 8.23782f
C2112 sg7 nr6 0.02483f
C2113 hsgs avdd 0.77131f
C2114 sg3 q3 0.04545f
C2115 rb5 nr4 0.01437f
C2116 ain nr3 0
C2117 b5 rb0 0.07299f
C2118 sr9 rb8 0.06713f
C2119 sr8 d0 0.04146f
C2120 sample rb8 0.00295f
C2121 d8 sg6 0.02562f
C2122 b3 rb0 0.0748f
C2123 a sr7 0.04924f
C2124 b7 rb6 0.15271f
C2125 nr2 gn1 0.0113f
C2126 vrefp rb6 2.40092f
C2127 azn d8 0.05702f
C2128 db6 sr6 0.06566f
C2129 gn4 gb5 0.01294f
C2130 rv328_adcfe_p2_0/gf180mcu_fd_sc_mcu9t5v0__nand3_1_7/a_271_69# gb1 0
C2131 rv328_adcfe_p2_0/gf180mcu_fd_sc_mcu9t5v0__nand3_1_5/a_455_69# avdd 0
C2132 sg4 sg5 37.73371f
C2133 sg2 bsn 0.01988f
C2134 azc d1b 0.53628f
C2135 rv328_adcfe_p2_0/gf180mcu_fd_sc_mcu9t5v0__nand3_1_19/a_455_69# avdd 0
C2136 hs sr1 0.75526f
C2137 rv328_adcfe_p2_0/gf180mcu_fd_sc_mcu9t5v0__nand3_1_20/a_271_69# avdd 0.00109f
C2138 sg3 nr1 0.01437f
C2139 db1 nr1 0.17788f
C2140 d1 sr1 0.15864f
C2141 sg8 sr1 0.07863f
C2142 a rb8 0.04924f
C2143 rb4 d6 0.01833f
C2144 b8 rb1 0.07435f
C2145 d9 sr1 0.03944f
C2146 nr7 gb6 0
C2147 d7 d6 13.97208f
C2148 gb3 db3 0.99016f
C2149 sr5 rb2 0.05268f
C2150 sr7 d0 0.04146f
C2151 sr3 ts 0.02088f
C2152 sr1 b9 0.04178f
C2153 bsn sg1 0.01988f
C2154 nr4 sr6 0.01899f
C2155 rv328_adcfe_p2_0/gf180mcu_fd_sc_mcu9t5v0__nand3_1_11/a_455_69# db0 0
C2156 sr4 bsb 0.2047f
C2157 hs sample 0.0344f
C2158 hs sr9 0.30112f
C2159 sg6 nr6 0.03408f
C2160 sg2 hsg 0.16068f
C2161 rb1 sr8 0.0972f
C2162 sg0 sr2 0.12231f
C2163 sg7 sr1 0.10855f
C2164 sr3 sr0 0.0464f
C2165 rb7 sr4 0.07012f
C2166 db3 rb9 0.03404f
C2167 rb3 rb2 35.78202f
C2168 rb4 rb0 0.06345f
C2169 nr2 avdd 0.82573f
C2170 rb0 d7 0.02039f
C2171 gn3 sr9 0.02989f
C2172 ts0 ts 4.22189f
C2173 sg5 d5 0.02343f
C2174 nr5 hsg 0.02338f
C2175 d1 sr9 0.02891f
C2176 rb8 d0 0.03672f
C2177 sg8 sample 0.01754f
C2178 xcmp_enb xcmp_d1 0.28268f
C2179 sg8 sr9 0.07476f
C2180 rb4 q3 0.04545f
C2181 q3 d7 0.05063f
C2182 rb9 gb6 0.0313f
C2183 d9 sample 0
C2184 d9 sr9 0.00272f
C2185 xcmp_a xcmp_o1 8.77792f
C2186 nr5 db5 0.25434f
C2187 sr5 d3 0.01739f
C2188 rv328_adcfe_p1_0/res1k_l60_n20_w1_0/a_n128_4500# rv328_adcfe_p1_0/res1k_l60_n20_w1_0/a_n128_3900# 0.04819f
C2189 azb sg9 0.02642f
C2190 sr0 ts0 0.01437f
C2191 hsn sg2 0.02022f
C2192 azn dn 0.15414f
C2193 sr9 b9 9.57921f
C2194 a hs 0.37535f
C2195 gn5 nr5 0.00256f
C2196 rb5 d6 0.03092f
C2197 b7 sg0 0.15886f
C2198 hsg sg1 0.14171f
C2199 vrefp sg0 0.57846f
C2200 a d1 0.04942f
C2201 d8 bsb 0.02242f
C2202 rb3 d3 0.02944f
C2203 rb1 sr7 0.05654f
C2204 sg7 sample 0.01759f
C2205 gn2 rb2 0.05683f
C2206 nr0 sr0 2.66759f
C2207 rb1 db2 0
C2208 db3 d4 0.02691f
C2209 sg7 sr9 0.06638f
C2210 nr3 sr8 0.01899f
C2211 sg4 nr2 0.01437f
C2212 rb7 d8 0.03687f
C2213 rb4 nr1 0.01437f
C2214 nr1 d7 0.01437f
C2215 a sg8 0.04924f
C2216 rv328_adcfe_p2_0/gf180mcu_fd_sc_mcu9t5v0__nand3_1_19/a_271_69# avdd 0.00109f
C2217 a d9 0.04926f
C2218 xcmp_y xcmp_azn 0.06512f
C2219 rv328_adcfe_p2_0/gf180mcu_fd_sc_mcu9t5v0__nand3_1_12/a_455_69# bsn 0.01168f
C2220 tsb b2 0
C2221 gb2 gn2 0.1027f
C2222 sr5 gb5 0.02875f
C2223 rb5 rb0 0.10229f
C2224 hsn sg1 0.02022f
C2225 hs d0 1.2439f
C2226 d8 db8 1.1196f
C2227 sr1 sg6 0.10645f
C2228 rb1 rb8 0.05104f
C2229 q2 rb2 0.04808f
C2230 rb9 ab 0.04534f
C2231 bs b2 1.99276f
C2232 a sg7 0.04924f
C2233 rb5 q3 0.04545f
C2234 d1 d0 6.34826f
C2235 rb2 gn1 0.02174f
C2236 sg8 d0 0.03672f
C2237 rv328_adcfe_p2_0/gf180mcu_fd_sc_mcu9t5v0__nand3_1_10/a_455_69# avdd 0
C2238 d3 gn2 0.04764f
C2239 sr7 nr3 0.01899f
C2240 b6 b2 0.11034f
C2241 db4 gb5 0.00252f
C2242 nr3 db2 0
C2243 sr3 d2 0.01739f
C2244 azn sr1 0.05702f
C2245 db3 rb6 0.02594f
C2246 d9 d0 0.03988f
C2247 sr9 gb7 0.03358f
C2248 hsb sr4 0.02462f
C2249 rv328_adcfe_p2_0/gf180mcu_fd_sc_mcu9t5v0__nand3_1_11/a_271_69# db0 0
C2250 sg3 sr4 0.10746f
C2251 ain b2 2.18419f
C2252 db1 sr4 0.02201f
C2253 nr2 d5 0.01437f
C2254 rb6 gb6 0.06184f
C2255 sr6 d6 0.30169f
C2256 gb2 gn1 0.01294f
C2257 b4 bsb 2.93658f
C2258 b4 rb7 0.03331f
C2259 nr6 bsb 0.00132f
C2260 rb7 nr6 0.02483f
C2261 rb5 nr1 0.01437f
C2262 vrefp gb9 0
C2263 d2 ts0 0.01905f
C2264 b5 sr4 0.08807f
C2265 d4 ab 0.03727f
C2266 q2 d3 0.02243f
C2267 sr9 sg6 0.06996f
C2268 sg7 d0 0.03672f
C2269 sample sg6 0.01766f
C2270 nr3 rb8 0.01437f
C2271 b3 sr4 0.04108f
C2272 gb1 db0 0
C2273 d3 gn1 0.019f
C2274 vcb top 0
C2275 xcmp_enb vbp 1.13172f
C2276 xcmp_azn xcmp_n1 0.15122f
C2277 azn sample 0.03444f
C2278 nr0 d2 0.01741f
C2279 xcmp_ym xcmp_o1 0.6413f
C2280 rb0 sr6 0.0612f
C2281 azn sr9 0.06703f
C2282 sg2 sg5 0.10612f
C2283 hsg bsn 0.01988f
C2284 azc dn 0.70359f
C2285 hsb d8 0.01895f
C2286 hs rb1 0.12251f
C2287 rb2 avdd 5.79005f
C2288 db6 nr7 0
C2289 sg3 d8 0.02043f
C2290 xcmp_oc avdd 0.2268f
C2291 nr5 sg5 0.02454f
C2292 xcmp_xm xcmp_a 0
C2293 vbp xcmp_o1 0.06075f
C2294 db1 d8 0.02505f
C2295 d1 rb1 0.09811f
C2296 sr6 q3 0.04545f
C2297 rv328_adcfe_p2_0/gf180mcu_fd_sc_mcu9t5v0__nand3_1_11/a_455_69# nr0 0.01168f
C2298 gb8 d8 0.03979f
C2299 gb4 sg3 0.02445f
C2300 sg8 rb1 0.09964f
C2301 az d6 0.02582f
C2302 a sg6 0.04924f
C2303 d9 rb1 0.01952f
C2304 rv328_adcfe_p2_0/gf180mcu_fd_sc_mcu9t5v0__nand3_1_12/a_271_69# bsn 0.00232f
C2305 sr5 sr2 0.04038f
C2306 gb2 avdd 0.54037f
C2307 rb6 ab 0.03727f
C2308 hsg nr9 0.07733f
C2309 sg9 ts 0.02069f
C2310 rv328_adcfe_p2_0/gf180mcu_fd_sc_mcu9t5v0__nand3_1_8/a_271_69# rb1 0.0029f
C2311 azn a 0.28475f
C2312 rb1 b9 0.04026f
C2313 rv328_adcfe_p2_0/gf180mcu_fd_sc_mcu9t5v0__nand3_1_20/a_455_69# avdd 0
C2314 vcb vt 6.8572f
C2315 xcmp_x top 0.08964f
C2316 sg5 sg1 0.10351f
C2317 nr1 sr6 0.01899f
C2318 rb0 az 0.02582f
C2319 sr1 bsb 0.24285f
C2320 rb4 sr4 1.94396f
C2321 hs nr3 1.88777f
C2322 sg4 rb2 0.05277f
C2323 rb1 sg7 0.05069f
C2324 sg9 sr0 12.6354f
C2325 rb3 sr2 0.07012f
C2326 rb7 sr1 0.07024f
C2327 rv328_adcfe_p2_0/gf180mcu_fd_sc_mcu9t5v0__nand3_1_10/a_271_69# avdd 0.00109f
C2328 d3 avdd 0.72242f
C2329 sr4 d7 0.03176f
C2330 b8 b2 0.18157f
C2331 gn3 nr3 0.0081f
C2332 azb ts 0.19221f
C2333 sg6 d0 0.03672f
C2334 bx sr0 0
C2335 sg8 nr3 0.01437f
C2336 hsg db5 0.13894f
C2337 b0 sr2 0.04229f
C2338 gn0 d6 0.01988f
C2339 b7 sr5 0.14456f
C2340 d9 nr3 0.01437f
C2341 vrefp sr5 1.95163f
C2342 gb3 nr4 0.00761f
C2343 b4 sg3 0.12434f
C2344 azn d0 0.06589f
C2345 gn5 hsg 1.42275f
C2346 azb sr0 0.02642f
C2347 b1 sr2 0.04461f
C2348 hsn hsg 0.23771f
C2349 sr8 b2 0.04429f
C2350 rv328_adcfe_p2_0/gf180mcu_fd_sc_mcu9t5v0__nand3_1_14/a_455_69# hsg 0
C2351 tsb sr3 0
C2352 b7 rb3 0.13575f
C2353 gn5 db5 4.71607f
C2354 gb0 db0 1.37166f
C2355 rv328_adcfe_p2_0/gf180mcu_fd_sc_mcu9t5v0__nand3_1_7/a_271_69# hs 0.00297f
C2356 vrefp rb3 0.80787f
C2357 sr9 bsb 0.17058f
C2358 b5 b4 47.85402f
C2359 gn0 rb0 0.34925f
C2360 gn2 sr2 0.00478f
C2361 sg2 nr2 0.02174f
C2362 rb7 sr9 0.06332f
C2363 sg9 nr8 0.02839f
C2364 d3 sg4 0.01739f
C2365 sg7 nr3 0.01437f
C2366 rb4 d8 0.01842f
C2367 nr4 rb9 0.02296f
C2368 sample rb7 0.00158f
C2369 bs sr3 0.17493f
C2370 b4 b3 49.23055f
C2371 gb5 avdd 0.52868f
C2372 d8 d7 15.48232f
C2373 gb4 rb4 0.02941f
C2374 b0 b7 0.11355f
C2375 b6 sr3 0.13651f
C2376 b0 vrefp 3.91399f
C2377 rb2 d5 0.01835f
C2378 tsb ts0 0.14122f
C2379 rv328_adcfe_p2_0/gf180mcu_fd_sc_mcu9t5v0__nand3_1_11/a_271_69# nr0 0.00232f
C2380 b7 b1 0.1077f
C2381 ain sr3 0.29711f
C2382 rb5 sr4 0.07012f
C2383 vrefp b1 1.14626f
C2384 bs ts0 0.0191f
C2385 q2 sr2 0.03437f
C2386 xcmp_xm xcmp_ym 0
C2387 sr8 db0 0
C2388 sr9 db8 0.04018f
C2389 rb1 sg6 0.05069f
C2390 sg0 ab 0.04534f
C2391 a bsb 0.05113f
C2392 a rb7 0.04924f
C2393 xcmp_x xcmp_y 2.64636f
C2394 nr2 sg1 0.00212f
C2395 sr2 gn1 0.02606f
C2396 bsn sg5 0.01988f
C2397 azc a 1.85716f
C2398 db6 rb6 0.03381f
C2399 nr4 d4 5.2811f
C2400 sg4 gb5 0.02445f
C2401 gn0 nr1 0.0082f
C2402 sg9 d2 0.02357f
C2403 azn rb1 0.05702f
C2404 hsb sr1 0.0246f
C2405 ain ts0 0
C2406 sg3 sr1 0.0713f
C2407 db1 sr1 0.04308f
C2408 d3 d5 0.02375f
C2409 hsgs bsn 0.15859f
C2410 b4 rb4 2.31664f
C2411 ain nr0 0
C2412 rb5 d8 0.02122f
C2413 d7 nr6 0.02034f
C2414 b5 sr1 0.07806f
C2415 azb d2 0.02664f
C2416 d0 bsb 4.03243f
C2417 sr7 db0 0
C2418 nr3 sg6 0.01437f
C2419 rb7 d0 0.03672f
C2420 b3 sr1 0.08046f
C2421 rb5 gb4 0
C2422 rv328_adcfe_p2_0/gf180mcu_fd_sc_mcu9t5v0__nand3_1_14/a_271_69# hsg 0.00297f
C2423 hsg sg5 0.23165f
C2424 sr4 sr6 0.06085f
C2425 nr4 rb6 0.01437f
C2426 hsb sr9 0.07753f
C2427 sr2 avdd 1.20329f
C2428 sg3 sr9 0.06621f
C2429 sg3 sample 0.01821f
C2430 azc xcmp_a 0.05012f
C2431 db1 sr9 0.03202f
C2432 gb5 d5 0.02377f
C2433 sg5 db5 0.05995f
C2434 rv328_adcfe_p2_0/gf180mcu_fd_sc_mcu9t5v0__nand2_1_0/a_245_69# bsb 0
C2435 azc xcmp_d1 1.82313f
C2436 gb8 sr9 0.03782f
C2437 hsg gn9 1.40326f
C2438 hsgs hsg 2.8954f
C2439 rb9 d6 0.02681f
C2440 b8 sr3 0.06515f
C2441 db9 sr9 0.10874f
C2442 gn5 sg5 1.79727f
C2443 xcmp_x xcmp_n1 2.00752f
C2444 sr5 db3 0.0229f
C2445 hsn sg5 0.02022f
C2446 sr0 ts 0.02072f
C2447 avdd vcm 0.09446f
C2448 a hsb 0.09611f
C2449 rv328_adcfe_p2_0/gf180mcu_fd_sc_mcu9t5v0__nand3_1_15/a_455_69# gb3 0
C2450 xcmp_d1 xcmp_azd 3.91405f
C2451 a sg3 0.04924f
C2452 b4 rb5 0.03331f
C2453 rv328_adcfe_p2_0/gf180mcu_fd_sc_mcu9t5v0__nand3_1_19/a_455_69# hsg 0
C2454 rb5 nr6 0
C2455 rv328_adcfe_p2_0/gf180mcu_fd_sc_mcu9t5v0__nand3_1_5/a_455_69# hsg 0
C2456 sr5 gb6 0
C2457 d8 sr6 0.02585f
C2458 b7 avdd 5.29967f
C2459 rv328_adcfe_p2_0/gf180mcu_fd_sc_mcu9t5v0__nand3_1_12/a_271_69# hsgs 0.00292f
C2460 rv328_adcfe_p2_0/gf180mcu_fd_sc_mcu9t5v0__nand3_1_20/a_271_69# hsg 0.00297f
C2461 sr4 az 0.02589f
C2462 sg8 b2 0.05201f
C2463 vrefp avdd 58.97763f
C2464 sg2 rb2 0.11429f
C2465 rb1 bsb 0.19342f
C2466 rb3 db3 0.06684f
C2467 db3 db4 0
C2468 sr3 sr8 0.07491f
C2469 sg4 sr2 0.1044f
C2470 rb1 rb7 0.08902f
C2471 rb4 sr1 0.11038f
C2472 rb0 rb9 0.07092f
C2473 xcmp_vbi top 0.99419f
C2474 hsn hsgs 0.4303f
C2475 sr1 d7 0.03944f
C2476 rv328_adcfe_p2_0/gf180mcu_fd_sc_mcu9t5v0__nand3_1_5/a_455_69# db5 0.00394f
C2477 gb0 nr0 0.32755f
C2478 rb9 q3 0.05352f
C2479 d4 d6 0.02375f
C2480 rv328_adcfe_p2_0/gf180mcu_fd_sc_mcu9t5v0__nand3_1_5/a_455_69# gn5 0.01168f
C2481 b9 b2 0.043f
C2482 gb2 sg2 2.25714f
C2483 sr8 ts0 0.01437f
C2484 hsb d0 0.02754f
C2485 hs db0 0.04455f
C2486 avdd rv328_adcfe_p2_0/gf180mcu_fd_sc_mcu9t5v0__nand3_1_4/a_271_69# 0
C2487 sg3 d0 0.03672f
C2488 tsb sg9 0
C2489 db1 d0 0
C2490 d1 db0 0
C2491 b7 sg4 0.13562f
C2492 rb2 sg1 0.10196f
C2493 vrefp sg4 0.46572f
C2494 d8 az 0.02582f
C2495 nr3 bsb 0.0014f
C2496 hsg nr2 0.02521f
C2497 d3 sg2 0.25164f
C2498 db3 gn2 0
C2499 nr0 sr8 0.02292f
C2500 rb4 sr9 0.06269f
C2501 sr7 sr3 0.035f
C2502 sr3 db2 0.0229f
C2503 gn0 sr4 0.01988f
C2504 gn7 sg9 0.0327f
C2505 rb7 nr3 0.01437f
C2506 rb9 nr1 0.02055f
C2507 rb0 d4 0.0201f
C2508 sample rb4 0
C2509 bs sg9 0.13081f
C2510 sr9 d7 0.03031f
C2511 sr5 ab 0.03727f
C2512 rv328_adcfe_p2_0/gf180mcu_fd_sc_mcu9t5v0__nand3_1_15/a_455_69# d4 0.00394f
C2513 bs bx 1.26528f
C2514 d4 q3 0.05063f
C2515 sr2 d5 0.03176f
C2516 azb tsb 0.03808f
C2517 sr6 nr6 1.78202f
C2518 rb6 d6 0.02713f
C2519 gb2 sg1 0.02445f
C2520 cmp xcmp_d1 3.36076f
C2521 ain sg9 0.11845f
C2522 rb5 sr1 0.07024f
C2523 b6 bx 0.20984f
C2524 d2 ts 0.02057f
C2525 azc xcmp_ym 0.59136f
C2526 bs azb 0.04283f
C2527 sr7 ts0 0.01437f
C2528 sr3 rb8 0.11974f
C2529 rb3 ab 0.03727f
C2530 a rb4 0.04924f
C2531 a d7 0.04927f
C2532 ain bx 2.69999f
C2533 azc vbp 0.14255f
C2534 d3 sg1 0.02043f
C2535 rv328_adcfe_p2_0/gf180mcu_fd_sc_mcu9t5v0__nand3_1_15/a_271_69# gb3 0
C2536 sr0 d2 0.03482f
C2537 gn0 d8 0.01988f
C2538 nr1 d4 0.01437f
C2539 gn4 nr4 0.0081f
C2540 sr7 nr0 0.0229f
C2541 rb0 rb6 0.09893f
C2542 rv328_adcfe_p2_0/gf180mcu_fd_sc_mcu9t5v0__nand3_1_19/a_271_69# hsg 0.00297f
C2543 xcmp_vbi xcmp_y 0.10238f
C2544 hsb rb1 0.02458f
C2545 azb ain 0
C2546 xcmp_enb xcmp_o3 0.54985f
C2547 sg3 rb1 0.0939f
C2548 nr5 gb5 0.15859f
C2549 rb8 ts0 0.01899f
C2550 db1 rb1 0.06787f
C2551 rb6 q3 0.04545f
C2552 vbp xcmp_azd 0.09883f
C2553 xcmp_o2 xcmp_oc 0.09275f
C2554 rb5 sr9 0.06121f
C2555 rb5 sample 0
C2556 b5 rb1 0.07266f
C2557 sg9 gn6 0.02962f
C2558 rb4 d0 0.03672f
C2559 nr0 rb8 0.01739f
C2560 b3 rb1 0.0748f
C2561 d0 d7 0.03996f
C2562 rv328_adcfe_p2_0/gf180mcu_fd_sc_mcu9t5v0__nand3_1_10/a_455_69# hsg 0
C2563 sr1 sr6 0.03591f
C2564 nr1 rb6 0.01437f
C2565 rb2 bsn 0.01988f
C2566 hs sr3 0.1842f
C2567 db3 avdd 0.44761f
C2568 gn3 sr3 0.00478f
C2569 sg3 nr3 0.02247f
C2570 a rb5 0.04924f
C2571 d1 sr3 0.0189f
C2572 q2 ab 0.04992f
C2573 sg8 sr3 0.07692f
C2574 sg0 d6 0.02043f
C2575 rv328_adcfe_p2_0/gf180mcu_fd_sc_mcu9t5v0__nand3_1_15/a_271_69# d4 0.00139f
C2576 b8 sg9 0.09617f
C2577 d9 sr3 0.03176f
C2578 avdd gb6 0.78767f
C2579 sr5 db6 0
C2580 hs ts0 0.01899f
C2581 ts dum 0.11776f
C2582 bx b8 3.85489f
C2583 xcmp_vbi xcmp_n1 0.05609f
C2584 sr3 b9 0.04178f
C2585 d1 ts0 0.01905f
C2586 d3 bsn 0.02003f
C2587 sr9 sr6 0.08693f
C2588 sample sr6 0.01739f
C2589 nr2 sg5 0.01437f
C2590 sg8 ts0 0.01437f
C2591 cmp vbp 0.54754f
C2592 sr1 az 0.02586f
C2593 d9 ts0 0.01899f
C2594 sg0 rb0 0.28995f
C2595 hsg rb2 2.89248f
C2596 hs nr0 2.74628f
C2597 sg2 sr2 0.14285f
C2598 sg9 sr8 0.3682f
C2599 sg7 sr3 0.10531f
C2600 db3 sg4 0.0229f
C2601 sr4 rb9 0.054f
C2602 rb1 rb4 0.05671f
C2603 rb1 d7 0.01926f
C2604 d8 nr7 0.02141f
C2605 rb5 d0 0.03672f
C2606 vbp b5 0
C2607 en xcmp_y 0.04337f
C2608 d1 nr0 0.01741f
C2609 vbp b3 0
C2610 bx sr8 0.04067f
C2611 sg8 nr0 0.01739f
C2612 sg0 q3 0.05352f
C2613 gn4 d6 0.02022f
C2614 tsb ts 20.32588f
C2615 d9 nr0 0.01739f
C2616 xcmp_b dum 0.2919f
C2617 gb2 hsg 0.02728f
C2618 sr5 nr4 0.01899f
C2619 azb sr8 0.02642f
C2620 rv328_adcfe_p2_0/gf180mcu_fd_sc_mcu9t5v0__nand3_1_8/a_455_69# db1 0.00394f
C2621 sg7 ts0 0.01437f
C2622 bs ts 0.02057f
C2623 sr9 gn8 0.04187f
C2624 a sr6 0.04924f
C2625 rb7 b2 0.03592f
C2626 bsb b2 2.64397f
C2627 gb4 gb3 0.51787f
C2628 rv328_adcfe_p2_0/gf180mcu_fd_sc_mcu9t5v0__nand3_1_20/a_455_69# hsg 0
C2629 hsn rb2 0.02022f
C2630 ab avdd 0.44301f
C2631 tsb sr0 0
C2632 b7 sg2 0.13562f
C2633 sr2 sg1 0.10887f
C2634 vrefp sg2 0.43254f
C2635 sample az 0
C2636 sr9 az 0.09382f
C2637 sg0 nr1 0.00147f
C2638 d3 hsg 0.05765f
C2639 nr4 db4 0.15654f
C2640 rb3 nr4 0
C2641 gn0 sr1 0.02392f
C2642 sr4 d4 0.03902f
C2643 sr7 sg9 0.35608f
C2644 sg9 db2 0.02908f
C2645 sg7 nr0 0.01739f
C2646 rb9 d8 0.07891f
C2647 nr3 rb4 0.01437f
C2648 bs sr0 0.25028f
C2649 rv328_adcfe_p2_0/gf180mcu_fd_sc_mcu9t5v0__nand3_1_10/a_271_69# hsg 0.00297f
C2650 nr3 d7 0.01437f
C2651 ain ts 0
C2652 b6 sr0 0.16332f
C2653 db3 d5 0.02685f
C2654 rb5 rb1 0.09421f
C2655 ain sr0 0.43104f
C2656 sr6 d0 0.04146f
C2657 azb sr7 0.02642f
C2658 sg9 rb8 0.06689f
C2659 sr3 sg6 0.10475f
C2660 sg4 ab 0.03727f
C2661 hsn d3 0.02022f
C2662 a az 0.14919f
C2663 b7 sg1 0.13562f
C2664 dn rv328_adcfe_p1_0/res1k_l60_n20_w1_0/a_n128_900# 0.0381f
C2665 vrefp sg1 0.48236f
C2666 en xcmp_n1 0.15033f
C2667 rv328_adcfe_p1_0/res1k_l60_n20_w1_0/a_n128_3900# rv328_adcfe_p1_0/res1k_l60_n20_w1_0/a_n128_3300# 0.04819f
C2668 hsg gb5 0.02369f
C2669 gn7 nr8 0.07016f
C2670 gn0 sr9 0.02957f
C2671 azn sr3 0.05702f
C2672 sr4 rb6 0.07012f
C2673 d8 d4 0.02173f
C2674 xcmp_azn xcmp_a 0.05012f
C2675 gb4 d4 0.02128f
C2676 azb rb8 0.02642f
C2677 sg6 ts0 0.01437f
C2678 gb5 db5 0.76658f
C2679 xcmp_azn xcmp_d1 0.01025f
C2680 rb9 nr6 0.03402f
C2681 rb5 nr3 0.01437f
C2682 xds_n2 dn 1.62771f
C2683 gn5 gb5 0.19094f
C2684 azn ts0 0.01923f
C2685 d0 az 0.02582f
C2686 nr0 sg6 0.01739f
C2687 rv328_adcfe_p2_0/gf180mcu_fd_sc_mcu9t5v0__nand3_1_14/a_455_69# gb5 0
C2688 sg3 b2 0.1038f
C2689 ab d5 0.03727f
C2690 sr5 d6 0.02883f
C2691 rb1 sr6 0.05654f
C2692 sr2 bsn 0.01988f
C2693 rb2 sg5 0.09658f
C2694 d8 rb6 0.0213f
C2695 bs d2 0.02038f
C2696 avdd top 4.68514f
C2697 hs sg9 0.25202f
C2698 gb1 d2 0.00711f
C2699 db6 avdd 0.46111f
C2700 gn3 sg9 0.02798f
C2701 d1 sg9 0.02294f
C2702 b5 b2 0.16887f
C2703 b3 b2 50.4408f
C2704 sg8 sg9 25.65319f
C2705 rb3 d6 0.01835f
C2706 db4 d6 0.02685f
C2707 b8 sr0 0.07116f
C2708 rv328_adcfe_p2_0/gf180mcu_fd_sc_mcu9t5v0__nand3_1_9/a_271_69# gb1 0.00292f
C2709 ain d2 0
C2710 sr5 rb0 0.0612f
C2711 gn0 d0 0.00136f
C2712 bx sg8 0.04895f
C2713 rv328_adcfe_p2_0/gf180mcu_fd_sc_mcu9t5v0__nand3_1_17/a_455_69# nr3 0.01168f
C2714 azb hs 0.02985f
C2715 sr8 ts 0.02352f
C2716 sg9 b9 10.09166f
C2717 azb d1 0.02671f
C2718 sr5 q3 0.04545f
C2719 db1 db0 0
C2720 azb sg8 0.02642f
C2721 nr3 sr6 0.01899f
C2722 d3 sg5 0.01739f
C2723 rb1 az 0.02582f
C2724 vt avdd 2.91975f
C2725 azb d9 0.02645f
C2726 sr3 bsb 0.15183f
C2727 db3 sg2 1.1206f
C2728 hsg sr2 0.20673f
C2729 sg0 sr4 0.1182f
C2730 sg7 sg9 0.08919f
C2731 sr0 sr8 0.08035f
C2732 rb7 sr3 0.07012f
C2733 rb9 sr1 0.04937f
C2734 rb3 rb0 0.10547f
C2735 bx b9 21.954f
C2736 nr4 avdd 0.82573f
C2737 sr9 nr7 0.03511f
C2738 rb3 q3 0.04545f
C2739 b4 rb6 0.03331f
C2740 b0 rb0 0.57692f
C2741 rb6 nr6 0.07916f
C2742 gn2 d6 0.02022f
C2743 sr5 nr1 0.01899f
C2744 vrefp nr9 0.0014f
C2745 azb sg7 0.02642f
C2746 ts0 bsb 0.02305f
C2747 xcmp_ym xcmp_azn 0.2028f
C2748 rv328_adcfe_p1_0/res1k_l60_n20_w1_0/a_n128_5100# dn 0.08688f
C2749 sr7 ts 0.02215f
C2750 rb7 ts0 0.01899f
C2751 b1 rb0 0.11693f
C2752 xcmp_tail2 top 0.13149f
C2753 hsn sr2 0.02022f
C2754 a rv328_adcfe_p1_0/res1k_l60_n20_w1_0/a_n128_900# 0.00667f
C2755 vbp xcmp_azn 0.04913f
C2756 rv328_adcfe_p1_0/res1k_l60_n20_w1_0/a_n128_2100# rv328_adcfe_p1_0/res1k_l60_n20_w1_0/a_n128_1500# 0.04819f
C2757 b7 hsg 0.13617f
C2758 sg5 gb5 3.29062f
C2759 vrefp hsg 0.49341f
C2760 nr0 bsb 0.00139f
C2761 sg0 d8 0.02043f
C2762 sr1 d4 0.03944f
C2763 rb9 sr9 17.26016f
C2764 nr8 sr8 6.71206f
C2765 rb2 nr2 0.02301f
C2766 gn4 sr4 0.0049f
C2767 sg4 nr4 0.02307f
C2768 sr7 sr0 0.03988f
C2769 rb3 nr1 0.01437f
C2770 gn0 rb1 0.02055f
C2771 rb7 nr0 0.01739f
C2772 sample rb9 3.32062f
C2773 q2 d6 0.02258f
C2774 xcmp_y avdd 2.86686f
C2775 sg9 gb7 0.0313f
C2776 azc xcmp_o3 0.99401f
C2777 gn1 d6 0.01899f
C2778 rb8 ts 0.02057f
C2779 gb2 nr2 0.23062f
C2780 xds_n2 a 0.12523f
C2781 sg9 sg6 0.08482f
C2782 sg2 ab 0.03727f
C2783 sr0 rb8 0.11958f
C2784 q2 rb0 5.74751f
C2785 xcmp_o3 xcmp_azd 0.2578f
C2786 rv328_adcfe_p2_0/gf180mcu_fd_sc_mcu9t5v0__nand3_1_17/a_271_69# nr3 0.00232f
C2787 a rb9 0.05327f
C2788 bs tsb 0
C2789 q2 q3 0.90729f
C2790 d3 nr2 0.02377f
C2791 d4 sr9 0.0274f
C2792 sr8 d2 0.01739f
C2793 azn sg9 0.05702f
C2794 sr1 rb6 0.07024f
C2795 gn4 d8 0.02022f
C2796 xcmp_b xcmp_o1 2.56016f
C2797 hsb sr3 0.02461f
C2798 rb5 b2 0.03404f
C2799 gb4 gn4 0.1027f
C2800 sg3 sr3 0.09278f
C2801 azb sg6 0.02642f
C2802 db1 sr3 0.02201f
C2803 nr4 d5 0.02406f
C2804 bs b6 4.9776f
C2805 b4 sg0 0.14559f
C2806 avdd d6 0.60375f
C2807 bs ain 28.45708f
C2808 sg1 ab 0.03727f
C2809 azn azb 4.53431f
C2810 b5 sr3 0.07806f
C2811 rv328_adcfe_p1_0/res1k_l60_n20_w1_0/a_12000_4800# rv328_adcfe_p1_0/res1k_l60_n20_w1_0/a_12000_5400# 0.04819f
C2812 nr8 rb8 0.06803f
C2813 rb9 d0 0.04479f
C2814 b3 sr3 0.94408f
C2815 hsb ts0 0
C2816 hs ts 0.05725f
C2817 a d4 0.0493f
C2818 xcmp_n1 avdd 0.58908f
C2819 xcmp_y xcmp_tail2 4.50202f
C2820 rv328_adcfe_p2_0/gf180mcu_fd_sc_mcu9t5v0__nand3_1_6/a_271_69# gn2 0.00232f
C2821 sg3 ts0 0.01437f
C2822 b6 ain 12.1472f
C2823 d1 ts 0.02057f
C2824 xcmp_x xcmp_a 2.46403f
C2825 nr1 gn1 0.01479f
C2826 gn7 db7 1.27104f
C2827 d2 db2 1.17872f
C2828 sr9 rb6 0.0637f
C2829 sr7 d2 0.01739f
C2830 sg8 ts 0.02067f
C2831 sr2 sg5 0.07154f
C2832 sample rb6 0
C2833 d9 ts 0.02057f
C2834 rv328_adcfe_p2_0/gf180mcu_fd_sc_mcu9t5v0__nand3_1_6/a_455_69# db2 0.00394f
C2835 hs sr0 0.50119f
C2836 rb0 avdd 2.59035f
C2837 sg3 nr0 0.01739f
C2838 rv328_adcfe_p2_0/gf180mcu_fd_sc_mcu9t5v0__nand3_1_9/a_455_69# hs 0
C2839 cmp xcmp_o3 1.2574f
C2840 xcmp_tail top 4.39626f
C2841 d1 sr0 0.04376f
C2842 db1 nr0 0
C2843 sg8 sr0 7.38803f
C2844 rv328_adcfe_p2_0/gf180mcu_fd_sc_mcu9t5v0__nand3_1_15/a_455_69# avdd 0
C2845 q3 avdd 1.93841f
C2846 hsgs sr2 0
C2847 sg4 d6 0.02043f
C2848 rv328_adcfe_p2_0/gf180mcu_fd_sc_mcu9t5v0__nand3_1_9/a_455_69# d1 0.00394f
C2849 d9 sr0 0.0348f
C2850 xcmp_y xcmp_vb 0.36006f
C2851 sr5 sr4 38.1832f
C2852 d4 d0 0.04038f
C2853 d2 rb8 0.01739f
C2854 sg7 ts 0.02066f
C2855 a rb6 0.04924f
C2856 rv328_adcfe_p2_0/gf180mcu_fd_sc_mcu9t5v0__nand3_1_11/a_271_69# gb0 0.00292f
C2857 sr0 b9 0.0478f
C2858 b7 sg5 0.13562f
C2859 vrefp sg5 0.26353f
C2860 sg9 bsb 4.51323f
C2861 db3 hsg 0.13697f
C2862 hs nr8 2.1471f
C2863 sr4 db4 0.04173f
C2864 sg0 sr1 0.12827f
C2865 rb3 sr4 0.11442f
C2866 rb7 sg9 0.06256f
C2867 sg4 rb0 0.0597f
C2868 sg7 sr0 3.21996f
C2869 sr3 rb4 0.12111f
C2870 rb1 rb9 0.06404f
C2871 nr1 avdd 0.71473f
C2872 sr3 d7 0.03176f
C2873 bx rb7 0.04579f
C2874 bx bsb 25.46212f
C2875 sg8 nr8 0.02855f
C2876 sg4 q3 0.04545f
C2877 gb1 gb0 0.00144f
C2878 b0 sr4 0.0414f
C2879 d1b q2 0.56311f
C2880 hsg gb6 0.05846f
C2881 bs b8 12.23562f
C2882 xcmp_tail2 xcmp_n1 2.81449f
C2883 d9 nr8 0.02043f
C2884 gb2 rb2 0.02941f
C2885 gb3 nr3 0.23062f
C2886 sr5 d8 0.01899f
C2887 db7 gn6 0
C2888 bsn ab 0.78692f
C2889 sr6 db0 0
C2890 rb6 d0 0.03672f
C2891 azb rb7 0.02642f
C2892 azb bsb 0.03097f
C2893 rb4 ts0 0.01899f
C2894 en b4 0
C2895 b1 sr4 0.04131f
C2896 d7 ts0 0.01899f
C2897 db5 gb6 0
C2898 sg9 db8 0.03912f
C2899 d5 d6 12.66949f
C2900 b6 b8 0.17701f
C2901 sr5 gb4 0
C2902 xcmp_xm xcmp_b 0
C2903 tsb sr8 0.00158f
C2904 azc azb 3.35975f
C2905 rv328_adcfe_p2_0/gf180mcu_fd_sc_mcu9t5v0__nand3_1_6/a_271_69# avdd 0.00109f
C2906 ain b8 69.69049f
C2907 gn5 gb6 0.00108f
C2908 rb1 d4 0.01909f
C2909 hs d2 1.40842f
C2910 nr2 sr2 2.78036f
C2911 sg7 nr8 0.00631f
C2912 gn7 sr8 0.03572f
C2913 d3 rb2 0.02771f
C2914 gn2 sr4 0.01988f
C2915 sg0 sr9 0.072f
C2916 sg4 nr1 0.01437f
C2917 sg0 sample 3.45447f
C2918 rb3 d8 0.01849f
C2919 nr3 rb9 0.02247f
C2920 rb4 nr0 0.01739f
C2921 d8 db4 0.02685f
C2922 bs sr8 0.10478f
C2923 nr0 d7 0.01739f
C2924 gb4 rb3 0
C2925 xcmp_n1 xcmp_vb 0.514f
C2926 gb4 db4 0.99016f
C2927 d1 d2 7.47929f
C2928 sg6 ts 0.02064f
C2929 b6 sr8 0.04127f
C2930 xcmp_x xcmp_ym 0.8348f
C2931 sg8 d2 0.01739f
C2932 rb0 d5 0.02017f
C2933 rv328_adcfe_p2_0/gf180mcu_fd_sc_mcu9t5v0__nand3_1_9/a_271_69# hs 0.00297f
C2934 rv328_adcfe_p2_0/gf180mcu_fd_sc_mcu9t5v0__nand3_1_11/a_455_69# hs 0
C2935 d9 d2 0.0211f
C2936 dn rv328_adcfe_p1_0/res1k_l60_n20_w1_0/a_n128_1500# 0.0381f
C2937 gb2 d3 0.00711f
C2938 rv328_adcfe_p2_0/gf180mcu_fd_sc_mcu9t5v0__nand3_1_15/a_271_69# avdd 0.00109f
C2939 rb5 sr3 0.07012f
C2940 ain sr8 0.0897f
C2941 xcmp_x vbp 0.11291f
C2942 rv328_adcfe_p2_0/gf180mcu_fd_sc_mcu9t5v0__nand3_1_9/a_271_69# d1 0.00139f
C2943 xcmp_o1 dum 0.04945f
C2944 q3 d5 0.05063f
C2945 azn ts 0.05711f
C2946 q2 sr4 0.03437f
C2947 sr0 sg6 1.38244f
C2948 hsg ab 0.03727f
C2949 tsb sr7 0
C2950 a sg0 0.05327f
C2951 d1b avdd 4.28431f
C2952 sr4 gn1 0.01988f
C2953 b4 sr5 0
C2954 gn2 d8 0.02022f
C2955 gn7 sr7 0.00704f
C2956 gn4 sr9 0.02989f
C2957 sg7 d2 0.01739f
C2958 azn sr0 0.05702f
C2959 rb1 rb6 0.0904f
C2960 nr3 d4 0.02393f
C2961 bs sr7 0.06411f
C2962 nr8 gb7 0
C2963 gb1 db2 0.19202f
C2964 hsb sg9 0.02458f
C2965 rb5 ts0 0.01899f
C2966 sg3 sg9 0.07273f
C2967 nr1 d5 0.01437f
C2968 db1 sg9 0.02604f
C2969 hsn ab 3.55881f
C2970 gb8 sg9 0.02758f
C2971 b4 rb3 0.14287f
C2972 bx sg3 0.04316f
C2973 db9 sg9 0.06988f
C2974 rb5 nr0 0.01739f
C2975 ain db2 0
C2976 ain sr7 0.1778f
C2977 sr9 gb9 0.10313f
C2978 b5 sg9 0
C2979 q2 d8 0.02292f
C2980 gn0 db0 2.7901f
C2981 sg0 d0 0.04494f
C2982 sr8 gn6 0.02043f
C2983 gn7 rb8 0.03517f
C2984 bs rb8 0.14544f
C2985 azb sg3 0.02642f
C2986 b0 b4 0.11727f
C2987 b5 bx 0.14491f
C2988 d8 gn1 0.01899f
C2989 bx b3 0.15319f
C2990 sr7 db7 0.16675f
C2991 sr3 sr6 0.04038f
C2992 db3 sg5 0.0229f
C2993 nr3 rb6 0.01437f
C2994 b4 b1 0.11423f
C2995 xcmp_vbi xcmp_a 0.97952f
C2996 sr4 avdd 1.17564f
C2997 ain rb8 0.04696f
C2998 xcmp_vbi xcmp_d1 0.22066f
C2999 gb0 sr8 0
C3000 sg5 gb6 0.02489f
C3001 sg2 d6 0.02043f
C3002 b8 sr8 7.55969f
C3003 rv328_adcfe_p2_0/gf180mcu_fd_sc_mcu9t5v0__nand3_1_11/a_271_69# hs 0.00297f
C3004 sr6 ts0 0.01437f
C3005 sr5 sr1 0.03737f
C3006 sr7 gn6 0.03001f
C3007 d2 sg6 0.01739f
C3008 nr5 d6 0.02043f
C3009 ts bsb 0.02071f
C3010 rb7 ts 0.02057f
C3011 tsb hs 0.04604f
C3012 azc ts 0.17691f
C3013 azn d2 0.0634f
C3014 nr0 sr6 0.0229f
C3015 sr3 az 0.02588f
C3016 sr0 bsb 0.22025f
C3017 hs gn7 0.02562f
C3018 sg0 rb1 0.36474f
C3019 sg4 sr4 0.14252f
C3020 rb2 sr2 1.84725f
C3021 db6 hsg 0.10272f
C3022 rb4 sg9 0.06769f
C3023 sg2 rb0 0.05979f
C3024 rb3 sr1 0.07024f
C3025 rb7 sr0 0.06995f
C3026 bs hs 0.01972f
C3027 d8 avdd 0.71488f
C3028 tsb sg8 0
C3029 sg9 d7 0.02875f
C3030 xcmp_o3 xcmp_azn 0.23804f
C3031 gb1 hs 1.26899f
C3032 gb0 sr7 0
C3033 rb8 gn6 0.01974f
C3034 bs d1 0.02103f
C3035 sg1 d6 0.02043f
C3036 gb4 avdd 0.54044f
C3037 bx rb4 0.01289f
C3038 sg8 gn7 0.0233f
C3039 gb1 d1 0.03281f
C3040 sg2 q3 0.04545f
C3041 bs sg8 0.11743f
C3042 dn q2 0.19918f
C3043 b0 sr1 0.04423f
C3044 b8 sr7 0.08079f
C3045 d9 gn7 0.02774f
C3046 a rv328_adcfe_p1_0/res1k_l60_n20_w1_0/a_n128_1500# 0
C3047 bs d9 0.01957f
C3048 rv328_adcfe_p2_0/gf180mcu_fd_sc_mcu9t5v0__nand3_1_0/a_271_69# rb8 0.00292f
C3049 sr5 sr9 0.07574f
C3050 sr5 sample 0.01739f
C3051 ain hs 0
C3052 gn5 db6 0
C3053 az ts0 0
C3054 sg5 ab 0.03727f
C3055 azb rb4 0.02642f
C3056 b6 sg8 0.04895f
C3057 ain gn3 0
C3058 b1 sr1 1.11357f
C3059 azb d7 0.02646f
C3060 azc xcmp_b 0.04912f
C3061 ain d1 0
C3062 bs b9 31.60231f
C3063 tsb sg7 0
C3064 ain sg8 0.0939f
C3065 b7 rb2 0.13583f
C3066 rb0 sg1 0.05981f
C3067 vrefp rb2 0.83728f
C3068 gn7 sg7 5.08094f
C3069 hsgs ab 0.05886f
C3070 gn0 sr3 0.01988f
C3071 rb3 sample 0
C3072 hsg nr4 0.02643f
C3073 d3 sr2 0.05056f
C3074 sr7 sr8 29.0341f
C3075 db4 sr9 0.03291f
C3076 rb3 sr9 0.06269f
C3077 sr8 db2 0.0229f
C3078 sg2 nr1 0.01437f
C3079 sg4 d8 0.02043f
C3080 b6 b9 0.14803f
C3081 b8 rb8 9.65788f
C3082 bs sg7 0.06652f
C3083 sr7 rv328_adcfe_p2_0/gf180mcu_fd_sc_mcu9t5v0__nand3_1_2/a_455_69# 0
C3084 en xcmp_a 0.21395f
C3085 gb4 sg4 1.86209f
C3086 sg1 q3 0.04545f
C3087 ain b9 93.04079f
C3088 a sr5 0.04924f
C3089 en xcmp_d1 0.21391f
C3090 b6 sg7 0
C3091 sr4 d5 0.05113f
C3092 b0 sr9 0
C3093 gb5 rv328_adcfe_p2_0/gf180mcu_fd_sc_mcu9t5v0__nand3_1_4/a_455_69# 0
C3094 xcmp_vbi xcmp_ym 0
C3095 b4 avdd 5.20895f
C3096 avdd nr6 1.33182f
C3097 rb5 sg9 0.06377f
C3098 ain sg7 0.07999f
C3099 q2 sr1 0.03437f
C3100 sr8 rb8 9.734f
C3101 nr8 db8 0.06863f
C3102 hs gn6 0.02606f
C3103 hsb ts 0
C3104 xcmp_vbi vbp 6.71718f
C3105 a rb3 0.04924f
C3106 bx rb5 0.05117f
C3107 sg3 ts 0.02057f
C3108 dn avdd 3.88466f
C3109 sr1 gn1 0.02364f
C3110 nr1 sg1 0.02059f
C3111 sg8 gn6 0.02043f
C3112 d2 bsb 0.02525f
C3113 sg7 db7 0.10536f
C3114 gn0 nr0 0.02802f
C3115 gn2 sr9 0.02989f
C3116 sr7 db2 0.0229f
C3117 rb7 d2 0.01739f
C3118 gn7 gb7 0.30109f
C3119 d9 gn6 0.0258f
C3120 hsb sr0 0.02458f
C3121 azb rb5 0.02642f
C3122 sr5 d0 0.04146f
C3123 sg3 sr0 0.30798f
C3124 db1 sr0 0
C3125 gb0 hs 1.3598f
C3126 d8 d5 0.01595f
C3127 bsn d6 0.01988f
C3128 b4 sg4 0.67167f
C3129 gb4 d5 0.00711f
C3130 gb0 d1 0
C3131 b5 sr0 0.0975f
C3132 q2 sr9 0.03437f
C3133 sg7 gn6 0.02982f
C3134 sr7 rb8 0.11473f
C3135 db2 rb8 0.02594f
C3136 rb3 d0 0.03672f
C3137 q2 sample 0.03442f
C3138 b3 sr0 0.10217f
C3139 bs sg6 0.10773f
C3140 rb6 b2 0.03469f
C3141 azn tsb 0.06478f
C3142 b8 sg8 4.96415f
C3143 xcmp_enb xcmp_o1 0
C3144 sr9 gn1 0.02989f
C3145 b6 sg6 1.53446f
C3146 db6 sg5 0.02202f
C3147 sg9 sr6 0.24706f
C3148 rb0 bsn 0.01988f
C3149 bs azn 1.87712f
C3150 db7 gb7 1.71149f
C3151 rv328_adcfe_p2_0/gf180mcu_fd_sc_mcu9t5v0__nand3_1_13/a_455_69# hs 0
C3152 hs sr8 0.2463f
C3153 sr1 avdd 1.67047f
C3154 ain sg6 0.12369f
C3155 gn3 sr8 0.01988f
C3156 b8 b9 48.42665f
C3157 hs rv328_adcfe_p2_0/gf180mcu_fd_sc_mcu9t5v0__nand3_1_2/a_455_69# 0
C3158 rv328_adcfe_p2_0/gf180mcu_fd_sc_mcu9t5v0__nand3_1_5/a_271_69# rb5 0.00292f
C3159 d1 sr8 0.0189f
C3160 sg8 sr8 0.12025f
C3161 gb8 nr8 0.36228f
C3162 a q2 0.09629f
C3163 hsg d6 0.09028f
C3164 b8 sg7 0.06515f
C3165 d9 sr8 0.03842f
C3166 azb sr6 0.02642f
C3167 gb5 rv328_adcfe_p2_0/gf180mcu_fd_sc_mcu9t5v0__nand3_1_4/a_271_69# 0
C3168 sr5 rb1 0.05654f
C3169 db7 sg6 0
C3170 en xcmp_ym 0.12883f
C3171 gn6 gb7 0.00471f
C3172 rb4 ts 0.02057f
C3173 d7 ts 0.02057f
C3174 db5 d6 0.05459f
C3175 sg9 gn8 0.0305f
C3176 sr8 b9 0.05128f
C3177 rv328_adcfe_p1_0/res1k_l60_n20_w1_0/a_12000_3000# rv328_adcfe_p1_0/res1k_l60_n20_w1_0/a_12000_3600# 0.04819f
C3178 en vbp 0.28052f
C3179 gn5 d6 0.0356f
C3180 nr4 sg5 0.01437f
C3181 sg9 az 0.02585f
C3182 rv328_adcfe_p2_0/gf180mcu_fd_sc_mcu9t5v0__nand3_1_20/a_271_69# db6 0.00139f
C3183 hs sr7 0.21344f
C3184 rb1 rb3 0.10196f
C3185 hsb d2 0.01895f
C3186 rb0 hsg 30.73257f
C3187 sg7 sr8 0.1198f
C3188 db3 rb2 0
C3189 hs db2 0.68301f
C3190 sg2 sr4 0.09903f
C3191 sg4 sr1 0.10487f
C3192 sr3 rb9 0.05302f
C3193 rb4 sr0 0.12045f
C3194 hsn d6 0.02022f
C3195 sr0 d7 0.0348f
C3196 sr9 avdd 14.34485f
C3197 sample avdd 0.31719f
C3198 gn3 sr7 0.01988f
C3199 sg3 d2 0.01739f
C3200 db1 d2 0.02511f
C3201 d1 db2 0
C3202 d1 sr7 0.0189f
C3203 q2 d0 0.031f
C3204 gn6 sg6 1.71878f
C3205 sg8 sr7 0.06843f
C3206 sg8 db2 0.0229f
C3207 hsg q3 4.58541f
C3208 d9 db2 0.02685f
C3209 d9 sr7 0.02559f
C3210 gb2 db3 0.19202f
C3211 sr5 nr3 0.01899f
C3212 azb az 0.71944f
C3213 dn xds_n1 1.74461f
C3214 rb9 ts0 0.01899f
C3215 b1 rb1 1.97412f
C3216 hs rb8 0.25401f
C3217 hsn rb0 0.02022f
C3218 sg0 b2 0.16045f
C3219 sr7 b9 0.0565f
C3220 gn3 rb8 0.01437f
C3221 a avdd 1.88656f
C3222 d1 rb8 0.0189f
C3223 b7 sr2 0.13562f
C3224 sr4 sg1 0.09901f
C3225 vrefp sr2 0.9055f
C3226 sg8 rb8 0.1172f
C3227 sg7 sr7 0.0744f
C3228 gn7 rb7 0.05103f
C3229 d3 db3 1.22044f
C3230 rb3 nr3 0.02375f
C3231 hsn q3 0.27369f
C3232 azc tsb 0.06299f
C3233 gn0 sg9 0.02392f
C3234 sample sg4 0.01792f
C3235 sg2 d8 0.02043f
C3236 bs bsb 60.05335f
C3237 bs rb7 0.11229f
C3238 hsg nr1 0.02887f
C3239 sr3 d4 0.05087f
C3240 sg4 sr9 0.06621f
C3241 sg7 db2 0.0229f
C3242 nr0 rb9 0.02143f
C3243 b8 sg6 0.06515f
C3244 rv328_adcfe_p1_0/res1k_l60_n20_w1_0/a_12000_4200# rv328_adcfe_p1_0/res1k_l60_n20_w1_0/a_12000_3600# 0.04819f
C3245 d9 rb8 0.03311f
C3246 sr8 gb7 0.02211f
C3247 rb5 ts 0.02057f
C3248 rv328_adcfe_p2_0/gf180mcu_fd_sc_mcu9t5v0__nand3_1_13/a_271_69# hs 0.00297f
C3249 nr5 d8 0.02043f
C3250 b6 bsb 3.47129f
C3251 b6 rb7 0.05974f
C3252 sr1 d5 0.03944f
C3253 hs rv328_adcfe_p2_0/gf180mcu_fd_sc_mcu9t5v0__nand3_1_2/a_271_69# 0.00297f
C3254 rb8 b9 0.07189f
C3255 rv328_adcfe_p2_0/gf180mcu_fd_sc_mcu9t5v0__nand3_1_0/a_455_69# db8 0.00394f
C3256 nr5 gb4 0.00771f
C3257 ain bsb 45.1418f
C3258 rb5 sr0 0.0699f
C3259 ain rb7 0.11846f
C3260 d4 ts0 0.01899f
C3261 gn7 db8 0
C3262 sg0 db0 0.78958f
C3263 sr8 sg6 0.10002f
C3264 sg7 rb8 0.11871f
C3265 q2 rb1 0.05402f
C3266 rb2 ab 0.03727f
C3267 d0 avdd 3.47353f
C3268 a sg4 0.04924f
C3269 b7 vrefp 7.13995f
C3270 rv328_adcfe_p2_0/gf180mcu_fd_sc_mcu9t5v0__nand3_1_6/a_271_69# hsg 0.00297f
C3271 rv328_adcfe_p1_0/res1k_l60_n20_w1_0/a_n128_300# dn 0.0381f
C3272 d8 sg1 0.02043f
C3273 rb1 gn1 0.47031f
C3274 nr3 gn2 0.0113f
C3275 b0 vbp 0
C3276 nr0 d4 0.01739f
C3277 rb7 db7 0.0331f
C3278 azn sr8 0.05702f
C3279 sr3 rb6 0.07012f
C3280 rb4 d2 0.01739f
C3281 d2 d7 0.0214f
C3282 xcmp_a avdd 1.09742f
C3283 sr7 gb7 0.05878f
C3284 xcmp_d1 avdd 2.08779f
C3285 gn3 hs 0.02108f
C3286 vbp b1 0
C3287 d1 hs 1.31371f
C3288 sr9 d5 0.02989f
C3289 rv328_adcfe_p2_0/gf180mcu_fd_sc_mcu9t5v0__nand2_1_0/a_245_69# avdd 0
C3290 sg5 d6 0.42826f
C3291 gb5 gb6 0.33078f
C3292 sg8 hs 0.2413f
C3293 b4 sg2 0.11349f
C3294 d9 hs 20.77209f
C3295 sg8 gn3 0.01988f
C3296 sg8 d1 0.0189f
C3297 d9 gn3 0.02022f
C3298 sr6 ts 0.0215f
C3299 rb6 ts0 0.01899f
C3300 d3 ab 0.03728f
C3301 db7 db8 0
C3302 sr7 sg6 0.06874f
C3303 db2 sg6 0.0229f
C3304 sg4 d0 0.03672f
C3305 rb7 gn6 0.02914f
C3306 d9 d1 0.02163f
C3307 rb8 gb7 0.02211f
C3308 d9 sg8 0.0451f
C3309 tsb hsb 0
C3310 en b2 0
C3311 azn sr7 0.05702f
C3312 sr4 bsn 0.01988f
C3313 rb0 sg5 0.10353f
C3314 sr0 sr6 0.04112f
C3315 nr0 rb6 0.01739f
C3316 a d5 0.04929f
C3317 hs sg7 0.21168f
C3318 bs hsb 0.01956f
C3319 sg8 b9 0.04724f
C3320 rb1 avdd 2.85368f
C3321 sg9 nr7 0.03561f
C3322 gn3 sg7 0.01988f
C3323 bs sg3 0.23216f
C3324 d1 sg7 0.0189f
C3325 rb8 sg6 0.10959f
C3326 sg5 q3 0.04545f
C3327 b4 sg1 0.11349f
C3328 rv328_adcfe_p2_0/gf180mcu_fd_sc_mcu9t5v0__nand3_1_2/a_271_69# gb7 0.00292f
C3329 sg8 sg7 31.4694f
C3330 gb1 db1 0.78721f
C3331 b8 bsb 10.12871f
C3332 b8 rb7 0.07989f
C3333 b6 sg3 0.13651f
C3334 d9 sg7 0.02628f
C3335 rb5 d2 0.01739f
C3336 rv328_adcfe_p2_0/gf180mcu_fd_sc_mcu9t5v0__nand3_1_0/a_271_69# db8 0.00139f
C3337 ain hsb 0
C3338 bs b5 3.58539f
C3339 az ts 0.47481f
C3340 a xds_n1 0.12722f
C3341 azn rb8 0.05702f
C3342 bs b3 2.83756f
C3343 ain sg3 0.30635f
C3344 hsgs q3 0.28286f
C3345 xcmp_azn xcmp_b 0.04912f
C3346 xcmp_tail2 xcmp_a 0.13149f
C3347 ain db1 0
C3348 sg7 b9 0.05561f
C3349 rv328_adcfe_p1_0/res1k_l60_n20_w1_0/a_n128_3900# dn 0.03811f
C3350 b6 b5 46.12204f
C3351 d0 d5 0.04016f
C3352 b6 b3 0.11331f
C3353 ain db9 0
C3354 d8 bsn 0.01988f
C3355 nr1 sg5 0.01437f
C3356 sr0 az 0.02585f
C3357 sg9 rb9 8.91712f
C3358 hsg sr4 0.24205f
C3359 db3 sr2 0
C3360 rb7 sr8 0.1089f
C3361 sg0 sr3 0.06463f
C3362 sr8 bsb 0.10756f
C3363 rb1 sg4 0.05074f
C3364 sg2 sr1 0.11569f
C3365 b5 ain 6.67836f
C3366 nr3 avdd 0.82573f
C3367 hs gb7 0.75787f
C3368 ain b3 3.86572f
C3369 rv328_adcfe_p2_0/gf180mcu_fd_sc_mcu9t5v0__nand3_1_16/a_455_69# gn3 0.01168f
C3370 rv328_adcfe_p2_0/gf180mcu_fd_sc_mcu9t5v0__nand3_1_8/a_455_69# gn1 0.01168f
C3371 sr4 db5 0
C3372 azb xds_n2 0.544f
C3373 sg8 gb7 0.02211f
C3374 nr2 d6 0.01437f
C3375 d9 gb7 0.02039f
C3376 xcmp_vb xcmp_a 0.06166f
C3377 azb rb9 0.02642f
C3378 sg0 ts0 0.01437f
C3379 hs sg6 0.21425f
C3380 sr8 db8 0.02999f
C3381 nr8 gn8 0.00192f
C3382 rb3 b2 0.03358f
C3383 rv328_adcfe_p2_0/gf180mcu_fd_sc_mcu9t5v0__nand3_1_20/a_455_69# db6 0.00394f
C3384 hsn sr4 0.02025f
C3385 vbp avdd 2.56665f
C3386 gn3 sg6 0.01988f
C3387 gb7 b9 0
C3388 rv328_adcfe_p1_0/res1k_l60_n20_w1_0/a_n128_300# a 0.0048f
C3389 d1 sg6 0.0189f
C3390 sr1 sg1 0.14284f
C3391 d2 sr6 0.01739f
C3392 sg8 sg6 0.12443f
C3393 rv328_adcfe_p2_0/gf180mcu_fd_sc_mcu9t5v0__nand3_1_7/a_271_69# avdd 0.00109f
C3394 db2 bsb 0
C3395 xcmp_o3 xcmp_vbi 0.12959f
C3396 sr7 bsb 0.11826f
C3397 sr7 rb7 3.27751f
C3398 gn0 sr0 0.02036f
C3399 sg0 nr0 0.02148f
C3400 hsg d8 0.13934f
C3401 azn hs 4.71488f
C3402 sg2 sr9 0.06621f
C3403 sg9 d4 0.02549f
C3404 sg4 nr3 0.01437f
C3405 sample sg2 0.01879f
C3406 rb7 db2 0.02594f
C3407 bs rb4 0.14192f
C3408 b0 b2 0.18903f
C3409 d9 sg6 0.02562f
C3410 sg7 gb7 1.29662f
C3411 bs d7 0.01963f
C3412 d1b q1 2.85492f
C3413 rv328_adcfe_p2_0/gf180mcu_fd_sc_mcu9t5v0__nand3_1_7/a_455_69# d2 0.00394f
C3414 azn d1 0.06441f
C3415 gb4 hsg 0.02728f
C3416 nr5 sr9 0.02439f
C3417 b6 rb4 0.13651f
C3418 rb1 d5 0.01914f
C3419 azn sg8 0.05702f
C3420 d8 db5 0.04468f
C3421 b1 b2 52.5942f
C3422 sg6 b9 0.05282f
C3423 azn d9 0.05702f
C3424 rv328_adcfe_p2_0/gf180mcu_fd_sc_mcu9t5v0__nand3_1_8/a_455_69# avdd 0
C3425 xcmp_enb azc 0.19023f
C3426 gb4 db5 0.19202f
C3427 ain rb4 0.59783f
C3428 gb0 db1 0.19202f
C3429 gn5 d8 0.01437f
C3430 b8 sg3 0.06515f
C3431 azb d4 0.0265f
C3432 rb8 bsb 0.0693f
C3433 sg7 sg6 34.93999f
C3434 rb7 rb8 26.6748f
C3435 sr2 ab 0.03727f
C3436 hsn d8 0.02022f
C3437 a sg2 0.04924f
C3438 azc xcmp_o1 0.56057f
C3439 sample sg1 0.0201f
C3440 sr9 sg1 0.06621f
C3441 d2 az 0.02582f
C3442 rv328_adcfe_p2_0/gf180mcu_fd_sc_mcu9t5v0__nand3_1_4/a_271_69# gb6 0.00292f
C3443 sg9 rb6 0.0633f
C3444 azn sg7 0.05702f
C3445 b5 b8 0.17522f
C3446 b8 b3 0.18028f
C3447 xcmp_enb xcmp_azd 0.34262f
C3448 db7 d7 1.28497f
C3449 hsb sr8 0.02468f
C3450 sg3 sr8 0.09686f
C3451 rv328_adcfe_p2_0/gf180mcu_fd_sc_mcu9t5v0__nand3_1_18/a_455_69# d8 0.00394f
C3452 bx rb6 0.04707f
C3453 rv328_adcfe_p2_0/gf180mcu_fd_sc_mcu9t5v0__nand3_1_16/a_271_69# gn3 0.00232f
C3454 db1 sr8 0.02201f
C3455 nr3 d5 0.01437f
C3456 xcmp_tail xcmp_a 2.12111f
C3457 rb8 db8 0.03645f
C3458 rv328_adcfe_p1_0/res1k_l60_n20_w1_0/a_n128_4500# dn 0.03818f
C3459 gb8 sr8 0.02902f
C3460 xcmp_azd xcmp_o1 0.13887f
C3461 vbp xcmp_tail2 0.16593f
C3462 b4 hsg 0.12237f
C3463 hsg nr6 0.03432f
C3464 bs rb5 0.18089f
C3465 azb rb6 0.02642f
C3466 vcb ts 0.62308f
C3467 b5 sr8 0.04127f
C3468 sg2 d0 0.03672f
C3469 rv328_adcfe_p1_0/res1k_l60_n20_w1_0/a_12000_1800# rv328_adcfe_p1_0/res1k_l60_n20_w1_0/a_12000_1200# 0.04819f
C3470 a sg1 0.04924f
C3471 b3 sr8 0.04255f
C3472 rv328_adcfe_p1_0/res1k_l60_n20_w1_0/a_n128_900# ts 0.00118f
C3473 gn6 d7 0.03765f
C3474 sg6 gb7 0.00104f
C3475 db5 nr6 0
C3476 b6 rb5 0.15597f
C3477 xcmp_ym xcmp_vb 1.05065f
C3478 gn0 d2 0.0199f
C3479 sr4 sg5 0.07176f
C3480 sr1 bsn 0.01988f
C3481 gn5 nr6 0.00823f
C3482 ain rb5 0.34579f
C3483 hs bsb 0.02577f
C3484 hs rb7 0.21258f
C3485 hsb sr7 0.02466f
C3486 xcmp_o3 en 0.19535f
C3487 gn3 bsb 0.0014f
C3488 sg3 sr7 0.05627f
C3489 sg3 db2 0.0229f
C3490 gn3 rb7 0.01437f
C3491 vbp xcmp_vb 0.0689f
C3492 d1 bsb 0.02662f
C3493 db1 db2 0
C3494 db1 sr7 0.02201f
C3495 d1 rb7 0.0189f
C3496 azc hs 1.02842f
C3497 sg8 rb7 0.10836f
C3498 sg8 bsb 0.11584f
C3499 xds_n2 ts 0.12045f
C3500 hsgs sr4 0
C3501 rb2 d6 0.01842f
C3502 b8 rb4 0.0741f
C3503 d9 bsb 0.02238f
C3504 d9 rb7 0.02702f
C3505 sg1 d0 0.03672f
C3506 sr5 sr3 0.04785f
C3507 azn sg6 0.05702f
C3508 xcmp_enb cmp 0.84635f
C3509 rb9 ts 0.0246f
C3510 hs db8 0.05615f
C3511 hsb rb8 0.02458f
C3512 tsb sr6 0
C3513 rb7 b9 0.04026f
C3514 bsb b9 19.5429f
C3515 sg3 rb8 0.10385f
C3516 avdd b2 1.88632f
C3517 db1 rb8 0.02505f
C3518 sr9 bsn 0.02798f
C3519 d8 sg5 0.01956f
C3520 bs sr6 0.1086f
C3521 gb8 rb8 0.03129f
C3522 sg8 db8 0.10735f
C3523 rb1 sg2 0.0519f
C3524 rb3 sr3 1.85257f
C3525 sg7 rb7 0.06425f
C3526 hsg sr1 0.19221f
C3527 sr3 db4 0
C3528 rb4 sr8 0.09335f
C3529 sg0 sg9 0.07439f
C3530 sg7 bsb 0.11432f
C3531 rb0 rb2 0.07327f
C3532 sr0 rb9 0.04475f
C3533 d9 db8 0.03048f
C3534 db9 rb8 0
C3535 sr8 d7 0.01955f
C3536 sr5 ts0 0.01437f
C3537 a rv328_adcfe_p2_0/gf180mcu_fd_sc_mcu9t5v0__nand3_1_12/a_455_69# 0.00394f
C3538 b6 sr6 1.77939f
C3539 rv328_adcfe_p2_0/gf180mcu_fd_sc_mcu9t5v0__nand3_1_2/a_455_69# d7 0.00394f
C3540 rv328_adcfe_p2_0/gf180mcu_fd_sc_mcu9t5v0__nand3_1_7/a_455_69# gb1 0
C3541 bx sg0 0.04607f
C3542 rv328_adcfe_p2_0/gf180mcu_fd_sc_mcu9t5v0__nand3_1_18/a_271_69# d8 0.00139f
C3543 rb2 q3 0.04545f
C3544 d3 d6 0.02237f
C3545 xcmp_x xcmp_b 0.36379f
C3546 rv328_adcfe_p2_0/gf180mcu_fd_sc_mcu9t5v0__nand3_1_0/a_455_69# gn8 0.01168f
C3547 ain sr6 0.22271f
C3548 azc xcmp_xm 0.57435f
C3549 sr5 nr0 0.0229f
C3550 top vcm 1.40742f
C3551 azb sg0 0.02642f
C3552 rb3 ts0 0.01899f
C3553 d4 ts 0.02057f
C3554 sr9 nr9 15.98182f
C3555 a bsn 5.72838f
C3556 sg7 db8 0
C3557 hsn sr1 0.02022f
C3558 db0 avdd 0.47457f
C3559 tsb az 0.66178f
C3560 b8 rb5 0.07397f
C3561 rb1 sg1 0.1345f
C3562 vbp xcmp_tail 0.17424f
C3563 bs az 0.02634f
C3564 sr0 d4 0.0348f
C3565 nr3 sg2 0.00212f
C3566 hsg sr9 0.36345f
C3567 sr3 gn2 0.02725f
C3568 sr7 rb4 0.05268f
C3569 sr4 nr2 0.01899f
C3570 gn4 sg9 0.02847f
C3571 rb9 nr8 0.02855f
C3572 rb4 db2 0.02594f
C3573 nr1 rb2 0.01437f
C3574 d3 rb0 0.02003f
C3575 rb3 nr0 0.01739f
C3576 sample hsg 0
C3577 rv328_adcfe_p2_0/gf180mcu_fd_sc_mcu9t5v0__nand3_1_10/a_271_69# rb0 0.00292f
C3578 sr7 d7 0.05812f
C3579 rb7 gb7 0.06072f
C3580 db2 d7 0.02685f
C3581 hs hsb 1.89796f
C3582 dn q1 2.14469f
C3583 sg3 hs 0.17131f
C3584 d1 hsb 0.01895f
C3585 d3 q3 0.0507f
C3586 gn3 sg3 2.83307f
C3587 db1 hs 0.05727f
C3588 sr9 db5 0.06112f
C3589 b4 sg5 0.09267f
C3590 sg5 nr6 0.01737f
C3591 gb5 d6 3.47574f
C3592 gb8 hs 0.57194f
C3593 d1 sg3 0.0189f
C3594 sg8 hsb 0.02458f
C3595 ain az 0
C3596 d9 hsb 0.01895f
C3597 d1 db1 1.06616f
C3598 db9 hs 0.03642f
C3599 sg8 sg3 0.10588f
C3600 rb5 sr8 0.09187f
C3601 bsn d0 0.02057f
C3602 sr6 gn6 0.0267f
C3603 vt vcm 2.39116f
C3604 gn5 sr9 0.02657f
C3605 sg9 gb9 2.6785f
C3606 rv328_adcfe_p2_0/gf180mcu_fd_sc_mcu9t5v0__nand3_1_6/a_455_69# gb3 0
C3607 sg8 db1 0.02201f
C3608 d9 sg3 0.02043f
C3609 rb6 ts 0.02057f
C3610 q2 sr3 0.03437f
C3611 rb7 sg6 0.06923f
C3612 sg6 bsb 0.10816f
C3613 rb4 rb8 0.05407f
C3614 d9 db1 0.02505f
C3615 sg8 gb8 4.89902f
C3616 hsn sr9 0.02839f
C3617 db8 gb7 0.02266f
C3618 rb8 d7 0.01997f
C3619 a hsg 0.04924f
C3620 rv328_adcfe_p2_0/gf180mcu_fd_sc_mcu9t5v0__nand3_1_6/a_271_69# rb2 0.00292f
C3621 db9 sg8 0.99096f
C3622 d9 gb8 0.42537f
C3623 d9 db9 1.43968f
C3624 sr3 gn1 0.01988f
C3625 b5 sg8 0.04895f
C3626 rv328_adcfe_p2_0/gf180mcu_fd_sc_mcu9t5v0__nand3_1_8/a_271_69# db1 0.00139f
C3627 sg3 b9 0.04122f
C3628 b3 sg8 0.05025f
C3629 d3 nr1 0.01438f
C3630 d8 nr2 0.01437f
C3631 azn bsb 0.07569f
C3632 rb9 d2 0.02476f
C3633 sr0 rb6 0.0699f
C3634 azn rb7 0.05702f
C3635 hsb sg7 0.02458f
C3636 gb1 gn0 0
C3637 sg3 sg7 0.05995f
C3638 azc azn 5.23936f
C3639 q2 ts0 0.01899f
C3640 db1 sg7 0.02201f
C3641 a rv328_adcfe_p2_0/gf180mcu_fd_sc_mcu9t5v0__nand3_1_12/a_271_69# 0.00139f
C3642 b5 b9 0.0437f
C3643 rv328_adcfe_p2_0/gf180mcu_fd_sc_mcu9t5v0__nand3_1_2/a_271_69# d7 0.00139f
C3644 b8 sr6 0.07736f
C3645 gb8 sg7 0
C3646 b3 b9 0.04308f
C3647 rb5 sr7 0.0512f
C3648 ain gn0 0
C3649 rb5 db2 0.02594f
C3650 rv328_adcfe_p2_0/gf180mcu_fd_sc_mcu9t5v0__nand3_1_0/a_271_69# gn8 0.00232f
C3651 hsg d0 0.08391f
C3652 rv328_adcfe_p2_0/gf180mcu_fd_sc_mcu9t5v0__nand3_1_4/a_455_69# d6 0.00394f
C3653 vcb dum 0
C3654 d4 d2 0.02375f
C3655 sr8 sr6 0.11688f
C3656 sr1 sg5 0.07228f
C3657 rb1 bsn 0.01988f
C3658 hs rb4 0.19258f
C3659 sr3 avdd 1.30897f
C3660 hs d7 0.16998f
C3661 rb5 rb8 0.06421f
C3662 gn3 rb4 0.02296f
C3663 gn3 d7 0.02022f
C3664 d1 rb4 0.0189f
C3665 hsn d0 0.02881f
C3666 d1 d7 0.02181f
C3667 sg8 rb4 0.10163f
C3668 sr2 d6 0.03176f
C3669 gb8 gb7 0
C3670 sg8 d7 0.01955f
C3671 d9 rb4 0.01849f
C3672 d9 d7 0.03551f
C3673 sr5 sg9 0.31853f
C3674 sg0 ts 0.0246f
C3675 sr8 gn8 0.00847f
C3676 hsb sg6 0.02458f
C3677 avdd ts0 0.74541f
C3678 rb4 b9 0.04152f
C3679 sg3 sg6 0.06275f
C3680 db1 sg6 0.02201f
C3681 rv328_adcfe_p2_0/gf180mcu_fd_sc_mcu9t5v0__nand2_1_0/a_245_69# hsn 0.0162f
C3682 xcmp_x dum 0.08968f
C3683 sr7 sr6 34.06359f
C3684 sr9 sg5 0.06517f
C3685 db2 sr6 0.0229f
C3686 sample sg5 0.01776f
C3687 d2 rb6 0.01739f
C3688 xcmp_o3 avdd 2.32835f
C3689 sr8 az 0.02603f
C3690 xcmp_o2 vbp 0.83122f
C3691 rb7 bsb 0.15665f
C3692 rb1 hsg 2.97332f
C3693 azn hsb 0.02182f
C3694 sg0 sr0 0.22746f
C3695 sr4 rb2 0.09541f
C3696 rb0 sr2 0.10746f
C3697 sg7 rb4 0.05276f
C3698 rb3 sg9 0.06078f
C3699 sg9 db4 0.031f
C3700 sg4 sr3 0.11502f
C3701 a q1 0.04822f
C3702 nr0 avdd 0.81162f
C3703 gn7 nr7 0
C3704 sg7 d7 0.02895f
C3705 azn sg3 0.05702f
C3706 azb sr5 0.02642f
C3707 b5 sg6 0
C3708 gb0 gn0 0.10283f
C3709 bx rb3 0.05525f
C3710 rv328_adcfe_p1_0/res1k_l60_n20_w1_0/a_12000_4200# rv328_adcfe_p1_0/res1k_l60_n20_w1_0/a_12000_4800# 0.04819f
C3711 sr9 gn9 0.01348f
C3712 sr2 q3 0.04545f
C3713 db6 gb6 1.14926f
C3714 hsgs sample 0
C3715 hsgs sr9 0.19144f
C3716 xcmp_enb xcmp_azn 0.09274f
C3717 rb5 hs 0.21624f
C3718 sr6 rb8 0.11255f
C3719 xcmp_vbi xcmp_b 6.80673f
C3720 azb rb3 0.02642f
C3721 sg4 ts0 0.01437f
C3722 rb5 gn3 0.01437f
C3723 b0 bx 1.75758f
C3724 a sg5 0.04924f
C3725 sg2 b2 0.48618f
C3726 rb5 d1 0.0189f
C3727 hsn rb1 0.02022f
C3728 xcmp_azn xcmp_o1 0.18389f
C3729 rb5 sg8 0.10421f
C3730 b7 rb0 0.136f
C3731 rb5 d9 0.02144f
C3732 bx b1 0.1772f
C3733 vrefp rb0 0.75986f
C3734 sr7 az 0.02597f
C3735 rv328_adcfe_p2_0/gf180mcu_fd_sc_mcu9t5v0__nand3_1_4/a_271_69# d6 0.00139f
C3736 db3 nr4 0
C3737 nr3 hsg 0.02594f
C3738 d3 sr4 0.01739f
C3739 nr1 sr2 0.01899f
C3740 gn0 sr8 0.01988f
C3741 gn2 sg9 0.02725f
C3742 sg4 nr0 0.01739f
C3743 gn7 rb9 0.03499f
C3744 rb2 d8 0.01858f
C3745 bs rb9 0.15368f
C3746 azc xcmp_azd 0.44622f
C3747 db7 nr7 0.07851f
C3748 a hsgs 0.02297f
C3749 gb7 d7 1.74296f
C3750 rb5 b9 0.04034f
C3751 rv328_adcfe_p2_0/gf180mcu_fd_sc_mcu9t5v0__nand3_1_5/a_271_69# sr5 0
C3752 b6 rb9 0.00174f
C3753 rb8 gn8 0.21553f
C3754 sr3 d5 0.03176f
C3755 top vss 30.64006f
C3756 vcm vss 49.69812f
C3757 vcb vss 4.70668f
C3758 vt vss 2.35655f
C3759 dum vss 18.39822f
C3760 nr6 vss 2.48644f
C3761 d6 vss 1.77452f
C3762 gb6 vss 2.00224f
C3763 rv328_adcfe_p2_0/gf180mcu_fd_sc_mcu9t5v0__nand3_1_4/a_455_69# vss 0.01436f ; **FLOATING
C3764 rv328_adcfe_p2_0/gf180mcu_fd_sc_mcu9t5v0__nand3_1_4/a_271_69# vss 0.01285f ; **FLOATING
C3765 ts vss 15.61865f
C3766 ts0 vss 2.19021f
C3767 avdd vss 1.55001p
C3768 nr9 vss 10.73588f
C3769 gb9 vss 2.77732f
C3770 rv328_adcfe_p2_0/gf180mcu_fd_sc_mcu9t5v0__nand3_1_3/a_455_69# vss 0.01428f ; **FLOATING
C3771 rv328_adcfe_p2_0/gf180mcu_fd_sc_mcu9t5v0__nand3_1_3/a_271_69# vss 0.01282f ; **FLOATING
C3772 az vss 2.35963f
C3773 nr7 vss 3.89923f
C3774 d7 vss 2.36547f
C3775 gb7 vss 2.25042f
C3776 rv328_adcfe_p2_0/gf180mcu_fd_sc_mcu9t5v0__nand3_1_2/a_455_69# vss 0.01491f ; **FLOATING
C3777 rv328_adcfe_p2_0/gf180mcu_fd_sc_mcu9t5v0__nand3_1_2/a_271_69# vss 0.01357f ; **FLOATING
C3778 db5 vss 2.43096f
C3779 d5 vss 2.48748f
C3780 q3 vss 4.89278f
C3781 gn9 vss 10.67506f
C3782 rv328_adcfe_p2_0/gf180mcu_fd_sc_mcu9t5v0__nand3_1_1/a_455_69# vss 0.01491f ; **FLOATING
C3783 rv328_adcfe_p2_0/gf180mcu_fd_sc_mcu9t5v0__nand3_1_1/a_271_69# vss 0.01357f ; **FLOATING
C3784 ab vss 4.78824f
C3785 db0 vss 1.43628f
C3786 d0 vss 3.0477f
C3787 sg6 vss 10.41857f
C3788 gn6 vss 2.58988f
C3789 gn8 vss 5.37668f
C3790 db8 vss 3.27098f
C3791 rb8 vss 9.40157f
C3792 rv328_adcfe_p2_0/gf180mcu_fd_sc_mcu9t5v0__nand3_1_0/a_455_69# vss 0.01421f ; **FLOATING
C3793 rv328_adcfe_p2_0/gf180mcu_fd_sc_mcu9t5v0__nand3_1_0/a_271_69# vss 0.01333f ; **FLOATING
C3794 sg1 vss 7.83212f
C3795 gn1 vss 1.30768f
C3796 gb5 vss 1.74751f
C3797 sg5 vss 7.24114f
C3798 db7 vss 1.68252f
C3799 rb6 vss 7.9057f
C3800 sr6 vss 9.16599f
C3801 bsn vss 4.92401f
C3802 db2 vss 2.15757f
C3803 d2 vss 2.38635f
C3804 sr9 vss 36.32582f
C3805 db4 vss 2.15147f
C3806 d4 vss 2.31663f
C3807 sr2 vss 10.25412f
C3808 nr2 vss 1.84309f
C3809 d8 vss 4.91754f
C3810 sr8 vss 18.82313f
C3811 nr8 vss 9.42575f
C3812 rb2 vss 4.26037f
C3813 sr1 vss 6.48102f
C3814 nr1 vss 4.55285f
C3815 rb9 vss 14.48266f
C3816 sr4 vss 8.80453f
C3817 nr4 vss 1.96995f
C3818 sr0 vss 5.83522f
C3819 nr0 vss 1.54993f
C3820 hsg vss 26.87006f
C3821 rb0 vss 4.1327f
C3822 sg9 vss 36.34533f
C3823 rb4 vss 4.16669f
C3824 sg2 vss 8.5477f
C3825 gn2 vss 1.46271f
C3826 db6 vss 1.34513f
C3827 sr3 vss 8.42756f
C3828 nr3 vss 1.90654f
C3829 rb7 vss 6.01687f
C3830 sr7 vss 12.34583f
C3831 sg4 vss 7.493f
C3832 gn4 vss 1.58114f
C3833 db3 vss 2.15453f
C3834 d3 vss 2.38311f
C3835 sample vss 3.00808f
C3836 sg7 vss 13.48968f
C3837 gn7 vss 3.74538f
C3838 rb3 vss 3.80465f
C3839 rb1 vss 4.52002f
C3840 sg0 vss 6.61939f
C3841 gn0 vss 1.32278f
C3842 hsb vss 2.32383f
C3843 hs vss 20.04221f
C3844 sg3 vss 5.95868f
C3845 gn3 vss 1.47449f
C3846 db1 vss 3.03311f
C3847 d1 vss 1.96425f
C3848 gb8 vss 3.11261f
C3849 sg8 vss 21.17072f
C3850 db9 vss 2.45615f
C3851 d9 vss 1.80279f
C3852 rv328_adcfe_p2_0/gf180mcu_fd_sc_mcu9t5v0__nand3_1_19/a_455_69# vss 0.01314f ; **FLOATING
C3853 rv328_adcfe_p2_0/gf180mcu_fd_sc_mcu9t5v0__nand3_1_19/a_271_69# vss 0.01176f ; **FLOATING
C3854 rv328_adcfe_p2_0/gf180mcu_fd_sc_mcu9t5v0__nand3_1_18/a_455_69# vss 0.01447f ; **FLOATING
C3855 rv328_adcfe_p2_0/gf180mcu_fd_sc_mcu9t5v0__nand3_1_18/a_271_69# vss 0.01256f ; **FLOATING
C3856 gb3 vss 1.56017f
C3857 rv328_adcfe_p2_0/gf180mcu_fd_sc_mcu9t5v0__nand3_1_17/a_455_69# vss 0.01384f ; **FLOATING
C3858 rv328_adcfe_p2_0/gf180mcu_fd_sc_mcu9t5v0__nand3_1_17/a_271_69# vss 0.01181f ; **FLOATING
C3859 rv328_adcfe_p2_0/gf180mcu_fd_sc_mcu9t5v0__nand3_1_16/a_455_69# vss 0.01414f ; **FLOATING
C3860 rv328_adcfe_p2_0/gf180mcu_fd_sc_mcu9t5v0__nand3_1_16/a_271_69# vss 0.01207f ; **FLOATING
C3861 gb4 vss 1.48695f
C3862 rv328_adcfe_p2_0/gf180mcu_fd_sc_mcu9t5v0__nand3_1_15/a_455_69# vss 0.01384f ; **FLOATING
C3863 rv328_adcfe_p2_0/gf180mcu_fd_sc_mcu9t5v0__nand3_1_15/a_271_69# vss 0.01181f ; **FLOATING
C3864 rv328_adcfe_p2_0/gf180mcu_fd_sc_mcu9t5v0__nand3_1_14/a_455_69# vss 0.01414f ; **FLOATING
C3865 rv328_adcfe_p2_0/gf180mcu_fd_sc_mcu9t5v0__nand3_1_14/a_271_69# vss 0.01207f ; **FLOATING
C3866 rv328_adcfe_p2_0/gf180mcu_fd_sc_mcu9t5v0__nand3_1_13/a_455_69# vss 0.01384f ; **FLOATING
C3867 rv328_adcfe_p2_0/gf180mcu_fd_sc_mcu9t5v0__nand3_1_13/a_271_69# vss 0.01181f ; **FLOATING
C3868 hsgs vss 3.25504f
C3869 rv328_adcfe_p2_0/gf180mcu_fd_sc_mcu9t5v0__nand3_1_12/a_455_69# vss 0.01392f ; **FLOATING
C3870 rv328_adcfe_p2_0/gf180mcu_fd_sc_mcu9t5v0__nand3_1_12/a_271_69# vss 0.01184f ; **FLOATING
C3871 hsn vss 4.14307f
C3872 rv328_adcfe_p2_0/gf180mcu_fd_sc_mcu9t5v0__nand2_1_0/a_245_69# vss 0.01067f ; **FLOATING
C3873 gb0 vss 2.07748f
C3874 rv328_adcfe_p2_0/gf180mcu_fd_sc_mcu9t5v0__nand3_1_11/a_455_69# vss 0.01379f ; **FLOATING
C3875 rv328_adcfe_p2_0/gf180mcu_fd_sc_mcu9t5v0__nand3_1_11/a_271_69# vss 0.0118f ; **FLOATING
C3876 rv328_adcfe_p2_0/gf180mcu_fd_sc_mcu9t5v0__nand3_1_10/a_455_69# vss 0.01392f ; **FLOATING
C3877 rv328_adcfe_p2_0/gf180mcu_fd_sc_mcu9t5v0__nand3_1_10/a_271_69# vss 0.01184f ; **FLOATING
C3878 gb1 vss 2.42875f
C3879 rv328_adcfe_p2_0/gf180mcu_fd_sc_mcu9t5v0__nand3_1_9/a_455_69# vss 0.01357f ; **FLOATING
C3880 rv328_adcfe_p2_0/gf180mcu_fd_sc_mcu9t5v0__nand3_1_9/a_271_69# vss 0.01225f ; **FLOATING
C3881 rv328_adcfe_p2_0/gf180mcu_fd_sc_mcu9t5v0__nand3_1_20/a_455_69# vss 0.01403f ; **FLOATING
C3882 rv328_adcfe_p2_0/gf180mcu_fd_sc_mcu9t5v0__nand3_1_20/a_271_69# vss 0.01242f ; **FLOATING
C3883 rv328_adcfe_p2_0/gf180mcu_fd_sc_mcu9t5v0__nand3_1_8/a_455_69# vss 0.01392f ; **FLOATING
C3884 rv328_adcfe_p2_0/gf180mcu_fd_sc_mcu9t5v0__nand3_1_8/a_271_69# vss 0.01184f ; **FLOATING
C3885 gb2 vss 1.63332f
C3886 rv328_adcfe_p2_0/gf180mcu_fd_sc_mcu9t5v0__nand3_1_7/a_455_69# vss 0.01384f ; **FLOATING
C3887 rv328_adcfe_p2_0/gf180mcu_fd_sc_mcu9t5v0__nand3_1_7/a_271_69# vss 0.01181f ; **FLOATING
C3888 tsb vss 4.93399f
C3889 rv328_adcfe_p2_0/gf180mcu_fd_sc_mcu9t5v0__nand3_1_6/a_455_69# vss 0.01414f ; **FLOATING
C3890 rv328_adcfe_p2_0/gf180mcu_fd_sc_mcu9t5v0__nand3_1_6/a_271_69# vss 0.01207f ; **FLOATING
C3891 gn5 vss 1.57935f
C3892 rb5 vss 5.28958f
C3893 rv328_adcfe_p2_0/gf180mcu_fd_sc_mcu9t5v0__nand3_1_5/a_455_69# vss 0.0146f ; **FLOATING
C3894 rv328_adcfe_p2_0/gf180mcu_fd_sc_mcu9t5v0__nand3_1_5/a_271_69# vss 0.01323f ; **FLOATING
C3895 sr5 vss 8.4818f
C3896 nr5 vss 1.45895f
C3897 b1 vss 10.92007f
C3898 b3 vss 10.82321f
C3899 vrefp vss 57.75421f
C3900 b8 vss 30.97581f
C3901 ain vss 0.10233p
C3902 b7 vss 23.85972f
C3903 bs vss 65.95095f
C3904 b5 vss 13.44168f
C3905 b2 vss 12.28586f
C3906 b0 vss 19.64479f
C3907 bx vss 22.65114f
C3908 b6 vss 19.64545f
C3909 bsb vss 31.78849f
C3910 b4 vss 12.74409f
C3911 azn vss 5.19925f
C3912 rv328_adcfe_p1_0/res1k_l60_n20_w1_0/a_12000_0# vss 0.59211f ; **FLOATING
C3913 rv328_adcfe_p1_0/res1k_l60_n20_w1_0/a_n128_300# vss 0.52995f ; **FLOATING
C3914 rv328_adcfe_p1_0/res1k_l60_n20_w1_0/a_12000_600# vss 0.55537f ; **FLOATING
C3915 rv328_adcfe_p1_0/res1k_l60_n20_w1_0/a_n128_900# vss 0.52713f ; **FLOATING
C3916 rv328_adcfe_p1_0/res1k_l60_n20_w1_0/a_12000_1200# vss 0.55491f ; **FLOATING
C3917 rv328_adcfe_p1_0/res1k_l60_n20_w1_0/a_n128_1500# vss 0.52509f ; **FLOATING
C3918 rv328_adcfe_p1_0/res1k_l60_n20_w1_0/a_12000_1800# vss 0.55477f ; **FLOATING
C3919 rv328_adcfe_p1_0/res1k_l60_n20_w1_0/a_n128_2100# vss 0.52237f ; **FLOATING
C3920 rv328_adcfe_p1_0/res1k_l60_n20_w1_0/a_12000_2400# vss 0.55477f ; **FLOATING
C3921 rv328_adcfe_p1_0/res1k_l60_n20_w1_0/a_n128_2700# vss 0.52237f ; **FLOATING
C3922 rv328_adcfe_p1_0/res1k_l60_n20_w1_0/a_12000_3000# vss 0.55477f ; **FLOATING
C3923 rv328_adcfe_p1_0/res1k_l60_n20_w1_0/a_n128_3300# vss 0.52237f ; **FLOATING
C3924 rv328_adcfe_p1_0/res1k_l60_n20_w1_0/a_12000_3600# vss 0.55477f ; **FLOATING
C3925 rv328_adcfe_p1_0/res1k_l60_n20_w1_0/a_n128_3900# vss 0.52237f ; **FLOATING
C3926 rv328_adcfe_p1_0/res1k_l60_n20_w1_0/a_12000_4200# vss 0.55491f ; **FLOATING
C3927 rv328_adcfe_p1_0/res1k_l60_n20_w1_0/a_n128_4500# vss 0.52269f ; **FLOATING
C3928 rv328_adcfe_p1_0/res1k_l60_n20_w1_0/a_12000_4800# vss 0.55537f ; **FLOATING
C3929 rv328_adcfe_p1_0/res1k_l60_n20_w1_0/a_n128_5100# vss 0.52345f ; **FLOATING
C3930 rv328_adcfe_p1_0/res1k_l60_n20_w1_0/a_12000_5400# vss 0.59211f ; **FLOATING
C3931 d1b vss 7.18114f
C3932 a vss 15.6215f
C3933 q1 vss 6.39996f
C3934 q2 vss 8.97506f
C3935 xds_n2 vss 3.73858f
C3936 azb vss 4.16673f
C3937 xds_n1 vss 1.77305f
C3938 dn vss 15.02608f
C3939 xcmp_o1 vss 5.40265f
C3940 xcmp_oc vss 10.26958f
C3941 xcmp_b vss 9.40438f
C3942 xcmp_a vss 10.2634f
C3943 xcmp_azd vss 7.41322f
C3944 xcmp_vb vss 16.22625f
C3945 xcmp_n1 vss 8.62997f
C3946 xcmp_tail2 vss 4.33135f
C3947 xcmp_d1 vss 11.14256f
C3948 xcmp_azn vss 3.62514f
C3949 xcmp_ym vss 2.18058f
C3950 xcmp_y vss 5.14995f
C3951 xcmp_xm vss 2.09078f
C3952 xcmp_tail vss 5.25984f
C3953 vbp vss 4.03912f
C3954 xcmp_vbi vss 6.28473f
C3955 en vss 7.45968f
C3956 xcmp_x vss 5.08826f
C3957 xcmp_enb vss 2.9699f
C3958 xcmp_o2 vss 5.06193f
C3959 azc vss 39.72789f
C3960 cmp vss 1.8554f
C3961 xcmp_o3 vss 3.29304f
C3962 b9 vss 46.06073f
* the capacitor array, a cell of its own (blocks/adccap.spice or its extracted netlist)
xcap top dum vss bx b0 b1 b2 b3 b4 b5 b6 b7 b8 b9 rv328_adc_caparray
.ends
