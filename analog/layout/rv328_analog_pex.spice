* rv328_analog with the wiring capacitance of its layout. Written by analog/layout/pex_block.py from rv328_analog.gds;
* same cell name and pins as the schematic. 2001 wiring capacitors, no wiring resistance;
* 89 transistor fingers; groups of 9 or more identical parallel ones are one line with m=.
* The blocks are the cells of analog/blocks (or their own extracted netlists, see sim.py); the gates and
* switches of the macro itself and the capacitance of the wiring between the blocks are from the layout.
* Not in here: capacitance between this wiring and the nodes inside a block.
* NGSPICE file created from rv328_analog.ext - technology: gf180mcuD

.subckt rv328_analog avdd vss xtal1 xtal2 aref adc7 adc6 adc5 adc4 adc3 adc2 adc1 adc0 ain0 ain1 clk_rc clk_xa clk_lf por_n bod_o rc_en rc_trim7 rc_trim6 rc_trim5 rc_trim4 rc_trim3 rc_trim2 rc_trim1 rc_trim0 xo_en xo_mode1 xo_mode0 bod_en bod_level2 bod_level1 bod_level0 adc_en adc_mux3 adc_mux2 adc_mux1 adc_mux0 adc_refs1 adc_refs0 adc_sample adc_dac9 adc_dac8 adc_dac7 adc_dac6 adc_dac5 adc_dac4 adc_dac3 adc_dac2 adc_dac1 adc_dac0 adc_cmp ac_en ac_bg ac_mux_en ac_out
X0 rv328_glue_0/rv328_glue_p0_0/gf180mcu_fd_sc_mcu9t5v0__nor2_1_2/ZN bod_en rv328_glue_0/rv328_glue_p0_0/gf180mcu_fd_sc_mcu9t5v0__nor2_1_2/a_234_573# avdd pfet_05v0 ad=0.8052p pd=4.54u as=0.5673p ps=2.45u w=1.83u l=0.5u
X1 vss bod_en rv328_glue_0/rv328_glue_p0_0/gf180mcu_fd_sc_mcu9t5v0__nor2_1_2/ZN vss nfet_05v0 ad=0.4048p pd=2.72u as=0.2392p ps=1.44u w=0.92u l=0.6u
X2 rv328_glue_0/rv328_glue_p0_0/gf180mcu_fd_sc_mcu9t5v0__nor2_1_2/a_234_573# adc_en avdd avdd pfet_05v0 ad=0.5673p pd=2.45u as=0.8052p ps=4.54u w=1.83u l=0.5u
X3 rv328_glue_0/rv328_glue_p0_0/gf180mcu_fd_sc_mcu9t5v0__nor2_1_2/ZN adc_en vss vss nfet_05v0 ad=0.2392p pd=1.44u as=0.4048p ps=2.72u w=0.92u l=0.6u
X4 rv328_glue_0/rv328_glue_p0_0/gf180mcu_fd_sc_mcu9t5v0__inv_1_0/I ac_en avdd avdd pfet_05v0 ad=0.4277p pd=2.165u as=0.7238p ps=4.17u w=1.645u l=0.5u
X5 avdd aco rv328_glue_0/rv328_glue_p0_0/gf180mcu_fd_sc_mcu9t5v0__inv_1_0/I avdd pfet_05v0 ad=0.7238p pd=4.17u as=0.4277p ps=2.165u w=1.645u l=0.5u
X6 rv328_glue_0/rv328_glue_p0_0/gf180mcu_fd_sc_mcu9t5v0__inv_1_0/I aco rv328_glue_0/rv328_glue_p0_0/gf180mcu_fd_sc_mcu9t5v0__nand2_1_0/a_245_69# vss nfet_05v0 ad=0.5808p pd=3.52u as=0.2112p ps=1.64u w=1.32u l=0.6u
X7 rv328_glue_0/rv328_glue_p0_0/gf180mcu_fd_sc_mcu9t5v0__nand2_1_0/a_245_69# ac_en vss vss nfet_05v0 ad=0.2112p pd=1.64u as=0.5808p ps=3.52u w=1.32u l=0.6u
X8 rv328_glue_0/rv328_glue_p0_0/gf180mcu_fd_sc_mcu9t5v0__inv_1_1/I adc_en avdd avdd pfet_05v0 ad=0.8554p pd=4.33u as=25.6568p ps=0.1458m w=1.645u l=0.5u
X9 avdd cmpa rv328_glue_0/rv328_glue_p0_0/gf180mcu_fd_sc_mcu9t5v0__inv_1_1/I avdd pfet_05v0 ad=0 pd=0 as=0 ps=0 w=1.645u l=0.5u
X10 rv328_glue_0/rv328_glue_p0_0/gf180mcu_fd_sc_mcu9t5v0__inv_1_1/I cmpa rv328_glue_0/rv328_glue_p0_0/gf180mcu_fd_sc_mcu9t5v0__nand2_1_1/a_245_69# vss nfet_05v0 ad=0.5808p pd=3.52u as=0.4224p ps=3.28u w=1.32u l=0.6u
X11 rv328_glue_0/rv328_glue_p0_0/gf180mcu_fd_sc_mcu9t5v0__nand2_1_1/a_245_69# adc_en vss vss nfet_05v0 ad=0 pd=0 as=14.6256p ps=90.24u w=1.32u l=0.6u
X12 rv328_glue_0/rv328_glue_p0_0/gf180mcu_fd_sc_mcu9t5v0__inv_1_2/I adc_en avdd avdd pfet_05v0 ad=0.8554p pd=4.33u as=0 ps=0 w=1.645u l=0.5u
X13 avdd adc_sample rv328_glue_0/rv328_glue_p0_0/gf180mcu_fd_sc_mcu9t5v0__inv_1_2/I avdd pfet_05v0 ad=0 pd=0 as=0 ps=0 w=1.645u l=0.5u
X14 rv328_glue_0/rv328_glue_p0_0/gf180mcu_fd_sc_mcu9t5v0__inv_1_2/I adc_sample rv328_glue_0/rv328_glue_p0_0/gf180mcu_fd_sc_mcu9t5v0__nand2_1_2/a_245_69# vss nfet_05v0 ad=0.5808p pd=3.52u as=0.4224p ps=3.28u w=1.32u l=0.6u
X15 rv328_glue_0/rv328_glue_p0_0/gf180mcu_fd_sc_mcu9t5v0__nand2_1_2/a_245_69# adc_en vss vss nfet_05v0 ad=0 pd=0 as=0 ps=0 w=1.32u l=0.6u
X16 mux_en rv328_glue_0/rv328_glue_p0_0/gf180mcu_fd_sc_mcu9t5v0__nand2_1_4/ZN avdd avdd pfet_05v0 ad=0.8554p pd=4.33u as=0 ps=0 w=1.645u l=0.5u
X17 avdd rv328_glue_0/rv328_glue_p0_0/gf180mcu_fd_sc_mcu9t5v0__inv_1_6/ZN mux_en avdd pfet_05v0 ad=0 pd=0 as=0 ps=0 w=1.645u l=0.5u
X18 mux_en rv328_glue_0/rv328_glue_p0_0/gf180mcu_fd_sc_mcu9t5v0__inv_1_6/ZN rv328_glue_0/rv328_glue_p0_0/gf180mcu_fd_sc_mcu9t5v0__nand2_1_3/a_245_69# vss nfet_05v0 ad=0.5808p pd=3.52u as=0.4224p ps=3.28u w=1.32u l=0.6u
X19 rv328_glue_0/rv328_glue_p0_0/gf180mcu_fd_sc_mcu9t5v0__nand2_1_3/a_245_69# rv328_glue_0/rv328_glue_p0_0/gf180mcu_fd_sc_mcu9t5v0__nand2_1_4/ZN vss vss nfet_05v0 ad=0 pd=0 as=0 ps=0 w=1.32u l=0.6u
X20 rv328_glue_0/rv328_glue_p0_0/gf180mcu_fd_sc_mcu9t5v0__nand2_1_4/ZN ac_mux_en avdd avdd pfet_05v0 ad=0.8554p pd=4.33u as=0 ps=0 w=1.645u l=0.5u
X21 avdd ac_en rv328_glue_0/rv328_glue_p0_0/gf180mcu_fd_sc_mcu9t5v0__nand2_1_4/ZN avdd pfet_05v0 ad=0 pd=0 as=0 ps=0 w=1.645u l=0.5u
X22 rv328_glue_0/rv328_glue_p0_0/gf180mcu_fd_sc_mcu9t5v0__nand2_1_4/ZN ac_en rv328_glue_0/rv328_glue_p0_0/gf180mcu_fd_sc_mcu9t5v0__nand2_1_4/a_245_69# vss nfet_05v0 ad=0.5808p pd=3.52u as=0.4224p ps=3.28u w=1.32u l=0.6u
X23 rv328_glue_0/rv328_glue_p0_0/gf180mcu_fd_sc_mcu9t5v0__nand2_1_4/a_245_69# ac_mux_en vss vss nfet_05v0 ad=0 pd=0 as=0 ps=0 w=1.32u l=0.6u
X24 bg_en rv328_glue_0/rv328_glue_p0_0/gf180mcu_fd_sc_mcu9t5v0__nor2_1_1/ZN avdd avdd pfet_05v0 ad=0.8554p pd=4.33u as=0 ps=0 w=1.645u l=0.5u
X25 avdd rv328_glue_0/rv328_glue_p0_0/gf180mcu_fd_sc_mcu9t5v0__nor2_1_2/ZN bg_en avdd pfet_05v0 ad=0 pd=0 as=0 ps=0 w=1.645u l=0.5u
X26 bg_en rv328_glue_0/rv328_glue_p0_0/gf180mcu_fd_sc_mcu9t5v0__nor2_1_2/ZN rv328_glue_0/rv328_glue_p0_0/gf180mcu_fd_sc_mcu9t5v0__nand2_1_5/a_245_69# vss nfet_05v0 ad=0.5808p pd=3.52u as=0.4224p ps=3.28u w=1.32u l=0.6u
X27 rv328_glue_0/rv328_glue_p0_0/gf180mcu_fd_sc_mcu9t5v0__nand2_1_5/a_245_69# rv328_glue_0/rv328_glue_p0_0/gf180mcu_fd_sc_mcu9t5v0__nor2_1_1/ZN vss vss nfet_05v0 ad=0 pd=0 as=0 ps=0 w=1.32u l=0.6u
X28 rv328_glue_0/rv328_glue_p0_0/gf180mcu_fd_sc_mcu9t5v0__inv_1_8/I rv328_glue_0/rv328_glue_p0_0/gf180mcu_fd_sc_mcu9t5v0__nand2_1_7/ZN avdd avdd pfet_05v0 ad=0.8554p pd=4.33u as=0 ps=0 w=1.645u l=0.5u
X29 avdd xo_en rv328_glue_0/rv328_glue_p0_0/gf180mcu_fd_sc_mcu9t5v0__inv_1_8/I avdd pfet_05v0 ad=0 pd=0 as=0 ps=0 w=1.645u l=0.5u
X30 rv328_glue_0/rv328_glue_p0_0/gf180mcu_fd_sc_mcu9t5v0__inv_1_8/I xo_en rv328_glue_0/rv328_glue_p0_0/gf180mcu_fd_sc_mcu9t5v0__nand2_1_6/a_245_69# vss nfet_05v0 ad=0.5808p pd=3.52u as=0.4224p ps=3.28u w=1.32u l=0.6u
X31 rv328_glue_0/rv328_glue_p0_0/gf180mcu_fd_sc_mcu9t5v0__nand2_1_6/a_245_69# rv328_glue_0/rv328_glue_p0_0/gf180mcu_fd_sc_mcu9t5v0__nand2_1_7/ZN vss vss nfet_05v0 ad=0 pd=0 as=0 ps=0 w=1.32u l=0.6u
X32 rv328_glue_0/rv328_glue_p0_0/gf180mcu_fd_sc_mcu9t5v0__nand2_1_7/ZN xo_mode0 avdd avdd pfet_05v0 ad=0.8554p pd=4.33u as=0 ps=0 w=1.645u l=0.5u
X33 avdd xo_mode1 rv328_glue_0/rv328_glue_p0_0/gf180mcu_fd_sc_mcu9t5v0__nand2_1_7/ZN avdd pfet_05v0 ad=0 pd=0 as=0 ps=0 w=1.645u l=0.5u
X34 rv328_glue_0/rv328_glue_p0_0/gf180mcu_fd_sc_mcu9t5v0__nand2_1_7/ZN xo_mode1 rv328_glue_0/rv328_glue_p0_0/gf180mcu_fd_sc_mcu9t5v0__nand2_1_7/a_245_69# vss nfet_05v0 ad=0.5808p pd=3.52u as=0.4224p ps=3.28u w=1.32u l=0.6u
X35 rv328_glue_0/rv328_glue_p0_0/gf180mcu_fd_sc_mcu9t5v0__nand2_1_7/a_245_69# xo_mode0 vss vss nfet_05v0 ad=0 pd=0 as=0 ps=0 w=1.32u l=0.6u
X36 ac_out rv328_glue_0/rv328_glue_p0_0/gf180mcu_fd_sc_mcu9t5v0__inv_1_0/I avdd avdd pfet_05v0 ad=0.8052p pd=4.54u as=0.8052p ps=4.54u w=1.83u l=0.5u
X37 ac_out rv328_glue_0/rv328_glue_p0_0/gf180mcu_fd_sc_mcu9t5v0__inv_1_0/I vss vss nfet_05v0 ad=0.5808p pd=3.52u as=0.5808p ps=3.52u w=1.32u l=0.6u
X38 smp rv328_glue_0/rv328_glue_p0_0/gf180mcu_fd_sc_mcu9t5v0__inv_1_2/I avdd avdd pfet_05v0 ad=0.8052p pd=4.54u as=0 ps=0 w=1.83u l=0.5u
X39 smp rv328_glue_0/rv328_glue_p0_0/gf180mcu_fd_sc_mcu9t5v0__inv_1_2/I vss vss nfet_05v0 ad=0.5808p pd=3.52u as=0 ps=0 w=1.32u l=0.6u
X40 adc_cmp rv328_glue_0/rv328_glue_p0_0/gf180mcu_fd_sc_mcu9t5v0__inv_1_1/I avdd avdd pfet_05v0 ad=0.8052p pd=4.54u as=0 ps=0 w=1.83u l=0.5u
X41 adc_cmp rv328_glue_0/rv328_glue_p0_0/gf180mcu_fd_sc_mcu9t5v0__inv_1_1/I vss vss nfet_05v0 ad=0.5808p pd=3.52u as=0 ps=0 w=1.32u l=0.6u
X42 en_avcc rv328_glue_0/rv328_glue_p0_0/gf180mcu_fd_sc_mcu9t5v0__inv_1_3/I avdd avdd pfet_05v0 ad=0.8052p pd=4.54u as=0 ps=0 w=1.83u l=0.5u
X43 en_avcc rv328_glue_0/rv328_glue_p0_0/gf180mcu_fd_sc_mcu9t5v0__inv_1_3/I vss vss nfet_05v0 ad=0.5808p pd=3.52u as=0 ps=0 w=1.32u l=0.6u
X44 en_buf rv328_glue_0/rv328_glue_p0_0/gf180mcu_fd_sc_mcu9t5v0__inv_1_4/I avdd avdd pfet_05v0 ad=0.8052p pd=4.54u as=0 ps=0 w=1.83u l=0.5u
X45 en_buf rv328_glue_0/rv328_glue_p0_0/gf180mcu_fd_sc_mcu9t5v0__inv_1_4/I vss vss nfet_05v0 ad=0.5808p pd=3.52u as=0 ps=0 w=1.32u l=0.6u
X46 rv328_glue_0/rv328_glue_p0_0/gf180mcu_fd_sc_mcu9t5v0__inv_1_5/ZN adc_refs1 avdd avdd pfet_05v0 ad=0.8052p pd=4.54u as=0 ps=0 w=1.83u l=0.5u
X47 rv328_glue_0/rv328_glue_p0_0/gf180mcu_fd_sc_mcu9t5v0__inv_1_5/ZN adc_refs1 vss vss nfet_05v0 ad=0.5808p pd=3.52u as=0 ps=0 w=1.32u l=0.6u
X48 rv328_glue_0/rv328_glue_p0_0/gf180mcu_fd_sc_mcu9t5v0__inv_1_6/ZN adc_en avdd avdd pfet_05v0 ad=0.8052p pd=4.54u as=0 ps=0 w=1.83u l=0.5u
X49 rv328_glue_0/rv328_glue_p0_0/gf180mcu_fd_sc_mcu9t5v0__inv_1_6/ZN adc_en vss vss nfet_05v0 ad=0.5808p pd=3.52u as=0 ps=0 w=1.32u l=0.6u
X50 lv1 rv328_glue_0/rv328_glue_p0_0/gf180mcu_fd_sc_mcu9t5v0__inv_1_7/I avdd avdd pfet_05v0 ad=0.8052p pd=4.54u as=0 ps=0 w=1.83u l=0.5u
X51 lv1 rv328_glue_0/rv328_glue_p0_0/gf180mcu_fd_sc_mcu9t5v0__inv_1_7/I vss vss nfet_05v0 ad=0.5808p pd=3.52u as=0 ps=0 w=1.32u l=0.6u
X52 rv328_glue_0/rv328_glue_p0_0/gf180mcu_fd_sc_mcu9t5v0__inv_1_8/ZN rv328_glue_0/rv328_glue_p0_0/gf180mcu_fd_sc_mcu9t5v0__inv_1_8/I avdd avdd pfet_05v0 ad=0.8052p pd=4.54u as=0 ps=0 w=1.83u l=0.5u
X53 rv328_glue_0/rv328_glue_p0_0/gf180mcu_fd_sc_mcu9t5v0__inv_1_8/ZN rv328_glue_0/rv328_glue_p0_0/gf180mcu_fd_sc_mcu9t5v0__inv_1_8/I vss vss nfet_05v0 ad=0.5808p pd=3.52u as=0 ps=0 w=1.32u l=0.6u
X54 avdd rv328_glue_0/rv328_glue_p0_0/gf180mcu_fd_sc_mcu9t5v0__inv_1_5/ZN rv328_glue_0/rv328_glue_p0_0/gf180mcu_fd_sc_mcu9t5v0__inv_1_3/I avdd pfet_05v0 ad=0.3796p pd=1.98u as=0.3796p ps=1.98u w=1.46u l=0.5u
X55 rv328_glue_0/rv328_glue_p0_0/gf180mcu_fd_sc_mcu9t5v0__nand3_1_0/a_271_69# adc_refs0 vss vss nfet_05v0 ad=0.2112p pd=1.64u as=0.5808p ps=3.52u w=1.32u l=0.6u
X56 rv328_glue_0/rv328_glue_p0_0/gf180mcu_fd_sc_mcu9t5v0__nand3_1_0/a_455_69# rv328_glue_0/rv328_glue_p0_0/gf180mcu_fd_sc_mcu9t5v0__inv_1_5/ZN rv328_glue_0/rv328_glue_p0_0/gf180mcu_fd_sc_mcu9t5v0__nand3_1_0/a_271_69# vss nfet_05v0 ad=0.2772p pd=1.74u as=0.2112p ps=1.64u w=1.32u l=0.6u
X57 rv328_glue_0/rv328_glue_p0_0/gf180mcu_fd_sc_mcu9t5v0__inv_1_3/I adc_en avdd avdd pfet_05v0 ad=0.6424p pd=3.8u as=0.3796p ps=1.98u w=1.46u l=0.5u
X58 rv328_glue_0/rv328_glue_p0_0/gf180mcu_fd_sc_mcu9t5v0__inv_1_3/I adc_en rv328_glue_0/rv328_glue_p0_0/gf180mcu_fd_sc_mcu9t5v0__nand3_1_0/a_455_69# vss nfet_05v0 ad=0.5808p pd=3.52u as=0.2772p ps=1.74u w=1.32u l=0.6u
X59 rv328_glue_0/rv328_glue_p0_0/gf180mcu_fd_sc_mcu9t5v0__inv_1_3/I adc_refs0 avdd avdd pfet_05v0 ad=0.3796p pd=1.98u as=0.6424p ps=3.8u w=1.46u l=0.5u
X60 avdd adc_refs1 rv328_glue_0/rv328_glue_p0_0/gf180mcu_fd_sc_mcu9t5v0__inv_1_4/I avdd pfet_05v0 ad=0 pd=0 as=1.4016p ps=7.76u w=1.46u l=0.5u
X61 rv328_glue_0/rv328_glue_p0_0/gf180mcu_fd_sc_mcu9t5v0__nand3_1_1/a_271_69# adc_refs0 vss vss nfet_05v0 ad=0.4224p pd=3.28u as=0 ps=0 w=1.32u l=0.6u
X62 rv328_glue_0/rv328_glue_p0_0/gf180mcu_fd_sc_mcu9t5v0__nand3_1_1/a_455_69# adc_refs1 rv328_glue_0/rv328_glue_p0_0/gf180mcu_fd_sc_mcu9t5v0__nand3_1_1/a_271_69# vss nfet_05v0 ad=0.5544p pd=3.48u as=0 ps=0 w=1.32u l=0.6u
X63 rv328_glue_0/rv328_glue_p0_0/gf180mcu_fd_sc_mcu9t5v0__inv_1_4/I adc_en avdd avdd pfet_05v0 ad=0 pd=0 as=0 ps=0 w=1.46u l=0.5u
X64 rv328_glue_0/rv328_glue_p0_0/gf180mcu_fd_sc_mcu9t5v0__inv_1_4/I adc_en rv328_glue_0/rv328_glue_p0_0/gf180mcu_fd_sc_mcu9t5v0__nand3_1_1/a_455_69# vss nfet_05v0 ad=0.5808p pd=3.52u as=0 ps=0 w=1.32u l=0.6u
X65 rv328_glue_0/rv328_glue_p0_0/gf180mcu_fd_sc_mcu9t5v0__inv_1_4/I adc_refs0 avdd avdd pfet_05v0 ad=0 pd=0 as=0 ps=0 w=1.46u l=0.5u
X66 rv328_glue_0/rv328_glue_p0_0/gf180mcu_fd_sc_mcu9t5v0__inv_1_7/I bod_level2 rv328_glue_0/rv328_glue_p0_0/gf180mcu_fd_sc_mcu9t5v0__nor2_1_0/a_234_573# avdd pfet_05v0 ad=0.8052p pd=4.54u as=1.1346p ps=4.9u w=1.83u l=0.5u
X67 vss bod_level2 rv328_glue_0/rv328_glue_p0_0/gf180mcu_fd_sc_mcu9t5v0__inv_1_7/I vss nfet_05v0 ad=0 pd=0 as=0.4784p ps=2.88u w=0.92u l=0.6u
X68 rv328_glue_0/rv328_glue_p0_0/gf180mcu_fd_sc_mcu9t5v0__nor2_1_0/a_234_573# bod_level1 avdd avdd pfet_05v0 ad=0 pd=0 as=0 ps=0 w=1.83u l=0.5u
X69 rv328_glue_0/rv328_glue_p0_0/gf180mcu_fd_sc_mcu9t5v0__inv_1_7/I bod_level1 vss vss nfet_05v0 ad=0 pd=0 as=0 ps=0 w=0.92u l=0.6u
X70 rv328_glue_0/rv328_glue_p0_0/gf180mcu_fd_sc_mcu9t5v0__nor2_1_1/ZN ac_en rv328_glue_0/rv328_glue_p0_0/gf180mcu_fd_sc_mcu9t5v0__nor2_1_1/a_234_573# avdd pfet_05v0 ad=0.8052p pd=4.54u as=1.1346p ps=4.9u w=1.83u l=0.5u
X71 vss ac_en rv328_glue_0/rv328_glue_p0_0/gf180mcu_fd_sc_mcu9t5v0__nor2_1_1/ZN vss nfet_05v0 ad=0 pd=0 as=0.4784p ps=2.88u w=0.92u l=0.6u
X72 rv328_glue_0/rv328_glue_p0_0/gf180mcu_fd_sc_mcu9t5v0__nor2_1_1/a_234_573# rv328_glue_0/rv328_glue_p0_0/gf180mcu_fd_sc_mcu9t5v0__inv_1_8/ZN avdd avdd pfet_05v0 ad=0 pd=0 as=0 ps=0 w=1.83u l=0.5u
X73 rv328_glue_0/rv328_glue_p0_0/gf180mcu_fd_sc_mcu9t5v0__nor2_1_1/ZN rv328_glue_0/rv328_glue_p0_0/gf180mcu_fd_sc_mcu9t5v0__inv_1_8/ZN vss vss nfet_05v0 ad=0 pd=0 as=0 ps=0 w=0.92u l=0.6u
X74 amx ac_mux_en acm vss nfet_06v0 ad=5p pd=21u as=5p ps=21u w=10u l=0.7u
X75 ain1 rv328_acsw_0/rv328_acsw_p0_0/gf180mcu_fd_sc_mcu9t5v0__inv_1_0/ZN acm vss nfet_06v0 ad=5p pd=21u as=10p ps=42u w=10u l=0.7u
X76 vref ac_bg acp vss nfet_06v0 ad=1p pd=5u as=1p ps=5u w=2u l=0.7u
X77 ain0 rv328_acsw_0/rv328_acsw_p0_0/gf180mcu_fd_sc_mcu9t5v0__inv_1_1/ZN acp vss nfet_06v0 ad=5p pd=21u as=6p ps=26u w=10u l=0.7u
X78 amx rv328_acsw_0/rv328_acsw_p0_0/gf180mcu_fd_sc_mcu9t5v0__inv_1_0/ZN acm avdd pfet_06v0 ad=2.8p pd=10.56u as=5p ps=21u w=10u l=0.55u
X79 acm rv328_acsw_0/rv328_acsw_p0_0/gf180mcu_fd_sc_mcu9t5v0__inv_1_0/ZN amx avdd pfet_06v0 ad=5p pd=21u as=2.8p ps=10.56u w=10u l=0.55u
X80 ain1 ac_mux_en acm avdd pfet_06v0 ad=5.6p pd=21.12u as=20p ps=84u w=10u l=0.55u
X81 acm ac_mux_en ain1 avdd pfet_06v0 ad=0 pd=0 as=0 ps=0 w=10u l=0.55u
X82 ain0 ac_bg acp avdd pfet_06v0 ad=5.6p pd=21.12u as=12p ps=51u w=10u l=0.55u
X83 acp ac_bg ain0 avdd pfet_06v0 ad=0 pd=0 as=0 ps=0 w=10u l=0.55u
X84 vref rv328_acsw_0/rv328_acsw_p0_0/gf180mcu_fd_sc_mcu9t5v0__inv_1_1/ZN acp avdd pfet_06v0 ad=2p pd=9u as=2p ps=9u w=4u l=0.55u
X85 rv328_acsw_0/rv328_acsw_p0_0/gf180mcu_fd_sc_mcu9t5v0__inv_1_0/ZN ac_mux_en avdd avdd pfet_05v0 ad=0.8052p pd=4.54u as=0 ps=0 w=1.83u l=0.5u
X86 rv328_acsw_0/rv328_acsw_p0_0/gf180mcu_fd_sc_mcu9t5v0__inv_1_0/ZN ac_mux_en vss vss nfet_05v0 ad=0.5808p pd=3.52u as=0 ps=0 w=1.32u l=0.6u
X87 rv328_acsw_0/rv328_acsw_p0_0/gf180mcu_fd_sc_mcu9t5v0__inv_1_1/ZN ac_bg avdd avdd pfet_05v0 ad=0.8052p pd=4.54u as=0 ps=0 w=1.83u l=0.5u
X88 rv328_acsw_0/rv328_acsw_p0_0/gf180mcu_fd_sc_mcu9t5v0__inv_1_1/ZN ac_bg vss vss nfet_05v0 ad=0.5808p pd=3.52u as=0 ps=0 w=1.32u l=0.6u
C0 ac_mux_en adc0 0.04853f
C1 bod_en ac_mux_en 0.0986f
C2 bod_en rv328_glue_0/rv328_glue_p0_0/gf180mcu_fd_sc_mcu9t5v0__inv_1_8/I 0.01563f
C3 smp adc_mux0 0.09024f
C4 cmpa rc_trim0 0.0452f
C5 mux_en adc7 0.05164f
C6 rc_trim1 adc_mux3 0.04044f
C7 adc_mux3 clk_xa 0.04044f
C8 rv328_glue_0/rv328_glue_p0_0/gf180mcu_fd_sc_mcu9t5v0__inv_1_7/I en_buf 0.01441f
C9 clk_rc adc_mux1 0.04548f
C10 adc_dac5 adc_mux1 0.04044f
C11 adc_dac7 xo_mode0 0.04044f
C12 ac_bg avdd 5.85595f
C13 clk_rc adc_en 0.09455f
C14 adc5 adc_mux2 0.04044f
C15 adc_dac5 adc_en 0.0913f
C16 rv328_glue_0/rv328_glue_p0_0/gf180mcu_fd_sc_mcu9t5v0__nand2_1_4/ZN cmpa 0.03315f
C17 rv328_glue_0/rv328_glue_p0_0/gf180mcu_fd_sc_mcu9t5v0__inv_1_6/ZN rv328_glue_0/rv328_glue_p0_0/gf180mcu_fd_sc_mcu9t5v0__inv_1_5/ZN 0.04484f
C18 acp adc_mux1 0
C19 ac_mux_en ain0 0.2521f
C20 vtemp adc_mux1 0.05581f
C21 acp adc_en 0.05168f
C22 lv1 bod_level0 49.8368f
C23 adc_dac0 ac_bg 0.04743f
C24 lv1 vbp 0.099f
C25 adc_en vtemp 0.05254f
C26 adc_dac8 rc_trim0 0.04044f
C27 adc_cmp rv328_glue_0/rv328_glue_p0_0/gf180mcu_fd_sc_mcu9t5v0__nor2_1_2/ZN 0.03449f
C28 rv328_glue_0/rv328_glue_p0_0/gf180mcu_fd_sc_mcu9t5v0__inv_1_4/I mux_en 0.06055f
C29 rc_trim2 cmpa 0.0452f
C30 rv328_glue_0/rv328_glue_p0_0/gf180mcu_fd_sc_mcu9t5v0__inv_1_2/I rv328_glue_0/rv328_glue_p0_0/gf180mcu_fd_sc_mcu9t5v0__inv_1_5/ZN 0
C31 aco rv328_glue_0/rv328_glue_p0_0/gf180mcu_fd_sc_mcu9t5v0__nand2_1_7/ZN 0.02046f
C32 smp ac_en 0.16998f
C33 ain1 adc_mux0 0
C34 rv328_glue_0/rv328_glue_p0_0/gf180mcu_fd_sc_mcu9t5v0__inv_1_2/I aref 0.00187f
C35 cmpa rv328_glue_0/rv328_glue_p0_0/gf180mcu_fd_sc_mcu9t5v0__nor2_1_1/ZN 0.02041f
C36 lv1 bod_level2 26.7911f
C37 xo_mode0 rv328_glue_0/rv328_glue_p0_0/gf180mcu_fd_sc_mcu9t5v0__nand2_1_7/a_245_69# 0
C38 rv328_glue_0/rv328_glue_p0_0/gf180mcu_fd_sc_mcu9t5v0__nand3_1_0/a_271_69# en_buf 0
C39 mux_en bg_en 0.04076f
C40 adc2 ac_mux_en 0.04044f
C41 acp rv328_acsw_0/rv328_acsw_p0_0/gf180mcu_fd_sc_mcu9t5v0__inv_1_0/ZN 0.10702f
C42 rc_trim3 adc_mux2 0.04044f
C43 adc_dac1 rc_trim0 0.04044f
C44 adc_dac3 ac_bg 0.04179f
C45 lv1 por_n 0.04908f
C46 rc_trim1 rc_trim5 0.04088f
C47 ac_mux_en adc_dac9 0.0452f
C48 rc_trim2 adc_dac8 0.04044f
C49 acm avdd 4.28785f
C50 adc4 vtemp 0.00709f
C51 vref adc5 0.05254f
C52 smp rc_trim7 0.04844f
C53 ain1 ac_en 0.04853f
C54 adc_refs0 adc_mux2 0.07524f
C55 rv328_glue_0/rv328_glue_p0_0/gf180mcu_fd_sc_mcu9t5v0__nand2_1_3/a_245_69# mux_en 0.0162f
C56 rc_trim2 adc_dac1 0.04044f
C57 bod_level1 adc_mux0 0.04044f
C58 adc0 adc_mux2 0.04853f
C59 bod_en adc_mux2 0.04044f
C60 ac_out rv328_glue_0/rv328_glue_p0_0/gf180mcu_fd_sc_mcu9t5v0__inv_1_4/I 0.01841f
C61 cmpa adc_dac8 0.1174f
C62 clk_rc xo_mode0 0.05771f
C63 adc_dac5 xo_mode0 0.04044f
C64 ac_mux_en xo_en 0.1487f
C65 adc_cmp avdd 1.8347f
C66 rc_trim0 rc_en 35.6942f
C67 rc_trim3 vref 0.15243f
C68 xo_mode1 bg_en 0.04054f
C69 lv1 adc_en 0.05982f
C70 rv328_glue_0/rv328_glue_p0_0/gf180mcu_fd_sc_mcu9t5v0__inv_1_8/I xo_en 1.91149f
C71 ac_out bg_en 0.01505f
C72 adc_cmp adc_dac0 1.17589f
C73 smp rv328_glue_0/rv328_glue_p0_0/gf180mcu_fd_sc_mcu9t5v0__inv_1_3/I 0.05192f
C74 ac_bg adc_refs1 0.043f
C75 adc_dac1 cmpa 0.15793f
C76 amx ac_mux_en 1.11486f
C77 rv328_glue_0/rv328_glue_p0_0/gf180mcu_fd_sc_mcu9t5v0__nor2_1_2/a_234_573# rv328_glue_0/rv328_glue_p0_0/gf180mcu_fd_sc_mcu9t5v0__inv_1_8/I 0.00269f
C78 adc_sample rv328_glue_0/rv328_glue_p0_0/gf180mcu_fd_sc_mcu9t5v0__nand2_1_2/a_245_69# 0
C79 bod_level1 ac_en 0.31533f
C80 ac_bg rc_trim4 0.043f
C81 adc_dac7 adc_mux0 0.04044f
C82 rc_trim3 aref 0.13622f
C83 rc_trim6 avdd 0.55268f
C84 adc_mux3 bod_o 0.04548f
C85 vref adc_refs0 0.16861f
C86 rv328_glue_0/rv328_glue_p0_0/gf180mcu_fd_sc_mcu9t5v0__nand2_1_4/ZN aco 0.02573f
C87 adc_sample ac_mux_en 0.08983f
C88 adc_sample rv328_glue_0/rv328_glue_p0_0/gf180mcu_fd_sc_mcu9t5v0__inv_1_8/I 0.01437f
C89 rc_trim2 rc_en 0.05063f
C90 adc_dac0 rc_trim6 0.04608f
C91 ac_mux_en adc6 0.04044f
C92 vref adc0 0.20045f
C93 adc_cmp adc_dac3 0.04548f
C94 mux_en bod_level0 0.0406f
C95 bod_en vref 0.15748f
C96 adc1 ac_mux_en 0.04044f
C97 adc2 adc_mux2 0.04044f
C98 vbp mux_en 0.20959f
C99 adc_dac1 adc_dac8 0.04062f
C100 adc_refs0 rv328_glue_0/rv328_glue_p0_0/gf180mcu_fd_sc_mcu9t5v0__inv_1_5/ZN 0.81784f
C101 aref adc_refs0 0.13818f
C102 rv328_glue_0/rv328_glue_p0_0/gf180mcu_fd_sc_mcu9t5v0__inv_1_7/I rv328_glue_0/rv328_glue_p0_0/gf180mcu_fd_sc_mcu9t5v0__inv_1_6/ZN 0
C103 adc_dac9 adc_mux2 0.0452f
C104 adc_mux3 avdd 12.3918f
C105 aco rv328_glue_0/rv328_glue_p0_0/gf180mcu_fd_sc_mcu9t5v0__nor2_1_1/ZN 0.01761f
C106 rv328_glue_0/rv328_glue_p0_0/gf180mcu_fd_sc_mcu9t5v0__nand2_1_0/a_245_69# avdd 0
C107 rc_trim7 bod_level1 0.04044f
C108 adc_dac7 ac_en 0.04044f
C109 adc_dac3 rc_trim6 0.04044f
C110 rv328_glue_0/rv328_glue_p0_0/gf180mcu_fd_sc_mcu9t5v0__nand2_1_7/ZN bg_en 0.02046f
C111 bod_level2 mux_en 8.10161f
C112 adc_mux3 adc_dac0 0.04608f
C113 bod_en aref 0.13809f
C114 adc_dac4 bod_level0 0.04044f
C115 cmpa rc_en 0.0528f
C116 vref ain0 0.13964f
C117 vbp adc_dac4 0.04613f
C118 por_n mux_en 0.043f
C119 lv1 xo_mode0 0.13535f
C120 aco cmpa 0.10859f
C121 bod_level0 adc_dac6 0.04044f
C122 rc_trim3 adc_dac2 0.04044f
C123 bod_level2 adc_dac4 0.04804f
C124 vbp adc_dac6 0.04613f
C125 vref rv328_glue_0/rv328_glue_p0_0/gf180mcu_fd_sc_mcu9t5v0__inv_1_1/I 0
C126 rv328_glue_0/rv328_glue_p0_0/gf180mcu_fd_sc_mcu9t5v0__nor2_1_2/ZN en_avcc 0.04215f
C127 rc_trim7 adc_dac7 0.04044f
C128 adc_dac3 adc_mux3 0.04044f
C129 adc2 vref 0.05254f
C130 adc_dac8 rc_en 0.04804f
C131 adc3 vtemp 0.00883f
C132 adc_mux2 xo_en 0.04044f
C133 bod_level0 xo_mode1 0.04179f
C134 ac_out bod_level0 0.04179f
C135 adc_cmp adc_refs1 0.05892f
C136 bod_level2 adc_dac6 0.04804f
C137 clk_rc adc_mux0 0.04548f
C138 ac_out vbp 0.14816f
C139 adc_dac5 adc_mux0 0.04044f
C140 rc_trim5 avdd 0.55046f
C141 vbp xo_mode1 0.20228f
C142 rv328_glue_0/rv328_glue_p0_0/gf180mcu_fd_sc_mcu9t5v0__inv_1_0/I adc_en 0
C143 rv328_glue_0/rv328_glue_p0_0/gf180mcu_fd_sc_mcu9t5v0__inv_1_1/I rv328_glue_0/rv328_glue_p0_0/gf180mcu_fd_sc_mcu9t5v0__inv_1_5/ZN 0
C144 acp adc_mux0 0
C145 adc_refs0 adc_dac2 0.04044f
C146 vtemp adc_mux0 0.05581f
C147 aref rv328_glue_0/rv328_glue_p0_0/gf180mcu_fd_sc_mcu9t5v0__inv_1_1/I 0.00202f
C148 mux_en adc_mux1 0.10882f
C149 adc_dac0 rc_trim5 0.04608f
C150 adc_dac1 rc_en 0.04804f
C151 amx adc_mux2 0.05667f
C152 bod_level2 xo_mode1 0.10168f
C153 ac_out bod_level2 0
C154 mux_en adc_en 0.18863f
C155 rc_trim6 adc_refs1 0.0452f
C156 bod_en adc_dac2 0.04044f
C157 bod_o clk_xa 0.05164f
C158 adc_sample adc_mux2 0.04908f
C159 aref adc_dac9 0.30138f
C160 aco adc_dac1 0.04272f
C161 adc6 adc_mux2 0.04044f
C162 rc_trim4 rc_trim6 0.04216f
C163 ac_bg rv328_acsw_0/rv328_acsw_p0_0/gf180mcu_fd_sc_mcu9t5v0__inv_1_1/ZN 0.88612f
C164 rv328_glue_0/rv328_glue_p0_0/gf180mcu_fd_sc_mcu9t5v0__nand2_1_4/ZN rv328_glue_0/rv328_glue_p0_0/gf180mcu_fd_sc_mcu9t5v0__inv_1_4/I 0.00135f
C165 adc_dac4 adc_mux1 0.04044f
C166 adc1 adc_mux2 0.04044f
C167 clk_rc ac_en 0.09711f
C168 adc_dac5 ac_en 0.04044f
C169 acp ac_en 0.04736f
C170 adc_dac4 adc_en 0.0913f
C171 clk_lf ac_bg 0.06027f
C172 adc_dac3 rc_trim5 0.04044f
C173 vtemp ac_en 0.05254f
C174 vref xo_en 0.2082f
C175 adc_cmp en_buf 0.0568f
C176 rc_trim1 avdd 0.54558f
C177 avdd clk_xa 2.00315f
C178 rv328_glue_0/rv328_glue_p0_0/gf180mcu_fd_sc_mcu9t5v0__nand2_1_4/ZN bg_en 0
C179 adc_mux3 adc_refs1 0.04608f
C180 adc_dac6 adc_mux1 0.04044f
C181 adc_dac6 adc_en 0.0913f
C182 adc4 mux_en 0.043f
C183 avdd en_avcc 0.38141f
C184 adc_mux3 rc_trim4 0.04044f
C185 smp ac_mux_en 0.13068f
C186 rc_trim1 adc_dac0 0.04608f
C187 smp rv328_glue_0/rv328_glue_p0_0/gf180mcu_fd_sc_mcu9t5v0__inv_1_8/I 0.01437f
C188 aref xo_en 0.30786f
C189 vref amx 10.13639f
C190 xo_mode1 adc_mux1 0.04179f
C191 adc_sample vref 0.17647f
C192 ac_out adc_mux1 0.04179f
C193 adc_dac5 rc_trim7 0.04044f
C194 adc_en xo_mode1 0.13028f
C195 bg_en rv328_glue_0/rv328_glue_p0_0/gf180mcu_fd_sc_mcu9t5v0__nor2_1_1/ZN 0.86746f
C196 bod_level2 rv328_glue_0/rv328_glue_p0_0/gf180mcu_fd_sc_mcu9t5v0__nand2_1_7/ZN 0.02048f
C197 ac_out adc_en 0.11308f
C198 vref adc6 0.05254f
C199 rv328_glue_0/rv328_glue_p0_0/gf180mcu_fd_sc_mcu9t5v0__inv_1_7/I adc_refs0 0.0199f
C200 rv328_acsw_0/rv328_acsw_p0_0/gf180mcu_fd_sc_mcu9t5v0__inv_1_1/ZN acm 0.02799f
C201 adc_dac9 adc_dac2 0.04538f
C202 adc_dac3 rc_trim1 0.04044f
C203 amx aref 19.095f
C204 aref rv328_glue_0/rv328_glue_p0_0/gf180mcu_fd_sc_mcu9t5v0__nor2_1_2/a_234_573# 0.00153f
C205 rv328_glue_0/rv328_glue_p0_0/gf180mcu_fd_sc_mcu9t5v0__inv_1_4/I cmpa 0.03213f
C206 rv328_glue_0/rv328_glue_p0_0/gf180mcu_fd_sc_mcu9t5v0__nand2_1_4/ZN rv328_glue_0/rv328_glue_p0_0/gf180mcu_fd_sc_mcu9t5v0__nand2_1_3/a_245_69# 0
C207 adc1 vref 0.05254f
C208 adc_sample rv328_glue_0/rv328_glue_p0_0/gf180mcu_fd_sc_mcu9t5v0__inv_1_5/ZN 0.03495f
C209 bod_en rv328_glue_0/rv328_glue_p0_0/gf180mcu_fd_sc_mcu9t5v0__inv_1_7/I 0
C210 adc_cmp ok 0.05164f
C211 adc_sample aref 0.13799f
C212 mux_en xo_mode0 0.13423f
C213 cmpa bg_en 0.04145f
C214 ain1 ac_mux_en 0.84382f
C215 rc_trim5 adc_refs1 0.0452f
C216 rv328_glue_0/rv328_glue_p0_0/gf180mcu_fd_sc_mcu9t5v0__nand3_1_0/a_271_69# adc_refs0 0.00292f
C217 rc_trim5 rc_trim4 37.5921f
C218 adc_dac4 xo_mode0 0.04044f
C219 ok rc_trim6 0.08959f
C220 lv1 ac_en 0.0898f
C221 bod_level2 rv328_glue_0/rv328_glue_p0_0/gf180mcu_fd_sc_mcu9t5v0__inv_1_8/ZN 0
C222 adc_dac2 xo_en 0.04044f
C223 rv328_glue_0/rv328_glue_p0_0/gf180mcu_fd_sc_mcu9t5v0__nor2_1_2/ZN avdd 0.42162f
C224 bod_level0 rc_trim0 0.04044f
C225 vbp rc_trim0 0.14698f
C226 adc_dac6 xo_mode0 0.04044f
C227 adc_en rv328_glue_0/rv328_glue_p0_0/gf180mcu_fd_sc_mcu9t5v0__nand2_1_7/ZN 0.02054f
C228 ac_mux_en bod_level1 0.08115f
C229 amx adc_dac2 0.04709f
C230 bod_level1 rv328_glue_0/rv328_glue_p0_0/gf180mcu_fd_sc_mcu9t5v0__inv_1_8/I 0.01442f
C231 adc_refs1 clk_xa 0.06225f
C232 bod_level2 rc_trim0 0.05474f
C233 rc_trim1 adc_refs1 0.0452f
C234 xo_mode1 xo_mode0 92.02551f
C235 lv1 rc_trim7 0.08739f
C236 rc_trim1 rc_trim4 0.04122f
C237 smp adc_mux2 0.09024f
C238 en_avcc adc_refs1 0.07439f
C239 rc_trim2 bod_level0 0.04044f
C240 aco adc7 0.06028f
C241 vbp rc_trim2 0.13938f
C242 bod_o avdd 27.8286f
C243 rv328_glue_0/rv328_glue_p0_0/gf180mcu_fd_sc_mcu9t5v0__nand2_1_4/ZN bod_level2 0
C244 adc5 ac_bg 0.043f
C245 rc_trim2 bod_level2 0.04695f
C246 clk_lf adc_mux3 0.05771f
C247 ac_mux_en adc_dac7 0.04044f
C248 adc3 mux_en 0.043f
C249 bod_level2 rv328_glue_0/rv328_glue_p0_0/gf180mcu_fd_sc_mcu9t5v0__nor2_1_1/ZN 0.02135f
C250 cmpa bod_level0 0.09067f
C251 aco rv328_glue_0/rv328_glue_p0_0/gf180mcu_fd_sc_mcu9t5v0__inv_1_4/I 0.01437f
C252 rv328_glue_0/rv328_glue_p0_0/gf180mcu_fd_sc_mcu9t5v0__inv_1_7/I xo_en 0
C253 vbp cmpa 0.20799f
C254 rc_trim0 adc_mux1 0.04044f
C255 mux_en adc_mux0 10.5773f
C256 rc_trim3 ac_bg 0.043f
C257 ok rc_trim5 0.08961f
C258 en_avcc en_buf 43.93397f
C259 adc_en rc_trim0 0.08848f
C260 adc_dac0 avdd 13.4208f
C261 adc_cmp rv328_glue_0/rv328_glue_p0_0/gf180mcu_fd_sc_mcu9t5v0__inv_1_2/I 0.03487f
C262 smp vref 0.16018f
C263 aco bg_en 0.01523f
C264 xo_mode0 rv328_glue_0/rv328_glue_p0_0/gf180mcu_fd_sc_mcu9t5v0__nand2_1_7/ZN 1.06373f
C265 bod_level2 cmpa 5.63303f
C266 rv328_glue_0/rv328_glue_p0_0/gf180mcu_fd_sc_mcu9t5v0__nand2_1_5/a_245_69# rv328_glue_0/rv328_glue_p0_0/gf180mcu_fd_sc_mcu9t5v0__nor2_1_1/ZN 0
C267 bod_level0 adc_dac8 0.04044f
C268 smp rv328_glue_0/rv328_glue_p0_0/gf180mcu_fd_sc_mcu9t5v0__inv_1_5/ZN 0.10124f
C269 rv328_glue_0/rv328_glue_p0_0/gf180mcu_fd_sc_mcu9t5v0__nand2_1_4/ZN adc_en 0.42905f
C270 adc_sample rv328_glue_0/rv328_glue_p0_0/gf180mcu_fd_sc_mcu9t5v0__inv_1_7/I 0.02726f
C271 rv328_glue_0/rv328_glue_p0_0/gf180mcu_fd_sc_mcu9t5v0__inv_1_0/I ac_en 0.45688f
C272 adc_dac4 adc_mux0 0.04044f
C273 por_n cmpa 15.5071f
C274 smp aref 0.49858f
C275 ac_bg adc_refs0 0.05109f
C276 vbp adc_dac8 0.04613f
C277 rv328_glue_0/rv328_glue_p0_0/gf180mcu_fd_sc_mcu9t5v0__nor2_1_2/ZN adc_refs1 0.03978f
C278 adc_dac3 avdd 0.99898f
C279 rc_trim2 adc_mux1 0.04044f
C280 ac_bg adc0 0.05109f
C281 mux_en ac_en 0.16936f
C282 bod_level1 adc_mux2 0.04044f
C283 rc_trim2 adc_en 0.08088f
C284 bod_en ac_bg 0.043f
C285 adc_dac6 adc_mux0 0.04044f
C286 adc_dac1 bod_level0 0.04044f
C287 bod_level2 adc_dac8 0.04804f
C288 adc_dac3 adc_dac0 0.04144f
C289 ok rc_trim1 0.0903f
C290 ok clk_xa 0.10913f
C291 ain1 vref 0.3803f
C292 adc_en rv328_glue_0/rv328_glue_p0_0/gf180mcu_fd_sc_mcu9t5v0__nor2_1_1/ZN 0.0183f
C293 vbp adc_dac1 0.04613f
C294 rv328_glue_0/rv328_glue_p0_0/gf180mcu_fd_sc_mcu9t5v0__inv_1_8/ZN xo_mode0 0
C295 xo_mode1 adc_mux0 0.04179f
C296 ac_out adc_mux0 0.04179f
C297 ac_mux_en clk_rc 0.09455f
C298 adc_dac5 ac_mux_en 0.04044f
C299 adc_dac4 ac_en 0.04044f
C300 bod_level2 adc_dac1 0.04804f
C301 acp ac_mux_en 0.15269f
C302 ac_bg ain0 0.82198f
C303 cmpa adc_mux1 0.08564f
C304 ac_mux_en vtemp 0.05254f
C305 rc_trim7 mux_en 0.08344f
C306 rv328_glue_0/rv328_glue_p0_0/gf180mcu_fd_sc_mcu9t5v0__nor2_1_2/ZN en_buf 0.04215f
C307 cmpa adc_en 0.89716f
C308 clk_lf clk_xa 0.04908f
C309 adc_dac6 ac_en 0.04044f
C310 adc_dac7 adc_mux2 0.04044f
C311 smp adc_dac2 0.04608f
C312 vref bod_level1 0.15747f
C313 bod_level0 rc_en 0.04044f
C314 xo_mode1 ac_en 0.14161f
C315 adc_dac8 adc_mux1 0.04044f
C316 adc2 ac_bg 0.043f
C317 ac_out ac_en 1.18411f
C318 avdd adc_refs1 1.40596f
C319 vbp rc_en 0.15202f
C320 rc_trim7 adc_dac4 0.04044f
C321 adc_dac8 adc_en 0.0913f
C322 rc_trim4 avdd 0.54736f
C323 adc_dac0 adc_refs1 0.04608f
C324 aco bod_level0 0.04044f
C325 ac_bg adc_dac9 0.04655f
C326 rc_trim3 rc_trim6 0.04122f
C327 adc_mux3 adc5 0.04044f
C328 rv328_glue_0/rv328_glue_p0_0/gf180mcu_fd_sc_mcu9t5v0__nand3_1_1/a_271_69# rv328_glue_0/rv328_glue_p0_0/gf180mcu_fd_sc_mcu9t5v0__inv_1_4/I 0.00232f
C329 aref bod_level1 0.13622f
C330 vbp aco 0.14546f
C331 rv328_glue_0/rv328_glue_p0_0/gf180mcu_fd_sc_mcu9t5v0__inv_1_3/I mux_en 0
C332 bod_level2 rc_en 0.5091f
C333 adc_dac0 rc_trim4 0.04608f
C334 rc_trim7 adc_dac6 0.04044f
C335 adc_cmp adc_refs0 0.05556f
C336 rc_trim2 xo_mode0 0
C337 adc_dac1 adc_mux1 0.04044f
C338 acm ain0 10.17063f
C339 adc_dac1 adc_en 0.0913f
C340 xo_mode0 rv328_glue_0/rv328_glue_p0_0/gf180mcu_fd_sc_mcu9t5v0__nor2_1_1/ZN 0
C341 adc_cmp bod_en 0.06944f
C342 aco bod_level2 0
C343 adc_dac3 adc_refs1 0.04044f
C344 rc_trim7 xo_mode1 0.00128f
C345 adc_refs0 rc_trim6 0.04044f
C346 aco por_n 0.05164f
C347 adc_dac3 rc_trim4 0.04044f
C348 adc_mux3 rc_trim3 0.04044f
C349 avdd en_buf 0.29019f
C350 lv1 ac_mux_en 0.06395f
C351 bod_en rc_trim6 0.0882f
C352 ac_bg xo_en 0.043f
C353 lv1 rv328_glue_0/rv328_glue_p0_0/gf180mcu_fd_sc_mcu9t5v0__inv_1_8/I 0.01437f
C354 aref adc_dac7 0.2369f
C355 cmpa xo_mode0 0.0455f
C356 rv328_glue_0/rv328_glue_p0_0/gf180mcu_fd_sc_mcu9t5v0__nand2_1_7/ZN ac_en 0.02056f
C357 clk_rc adc_mux2 0.04548f
C358 adc_dac5 adc_mux2 0.04044f
C359 smp rv328_glue_0/rv328_glue_p0_0/gf180mcu_fd_sc_mcu9t5v0__inv_1_7/I 0.05247f
C360 ok bod_o 0
C361 acp adc_mux2 0
C362 rv328_glue_0/rv328_glue_p0_0/gf180mcu_fd_sc_mcu9t5v0__inv_1_2/I en_avcc 0
C363 adc_mux1 rc_en 0.04548f
C364 adc_mux2 vtemp 0.05581f
C365 adc_mux3 adc_refs0 1.75138f
C366 amx ac_bg 0.05868f
C367 adc_en rc_en 0.09352f
C368 bod_level1 adc_dac2 0.04044f
C369 ac_out rv328_glue_0/rv328_glue_p0_0/gf180mcu_fd_sc_mcu9t5v0__inv_1_3/I 0.02486f
C370 adc_sample ac_bg 0.05164f
C371 adc_mux3 adc0 0.04853f
C372 adc_cmp rv328_glue_0/rv328_glue_p0_0/gf180mcu_fd_sc_mcu9t5v0__inv_1_1/I 0.93883f
C373 adc_dac8 xo_mode0 0.04044f
C374 adc_mux3 bod_en 0.04608f
C375 aco adc_mux1 0.04044f
C376 ac_bg adc6 0.043f
C377 aco adc_en 0.10623f
C378 vbp adc7 0.05509f
C379 adc_cmp adc_dac9 0.05024f
C380 rc_trim0 adc_mux0 0.04044f
C381 adc1 ac_bg 0.043f
C382 ok avdd 39.7284f
C383 rc_trim3 rc_trim5 0.04216f
C384 clk_lf bod_o 0.57967f
C385 adc_dac1 xo_mode0 0.04044f
C386 rv328_glue_0/rv328_glue_p0_0/gf180mcu_fd_sc_mcu9t5v0__inv_1_8/ZN ac_en 0.13979f
C387 rc_trim4 adc_refs1 0.0452f
C388 vref clk_rc 0.17287f
C389 adc_dac7 adc_dac2 0.0408f
C390 adc_dac9 rc_trim6 0.0452f
C391 rv328_acsw_0/rv328_acsw_p0_0/gf180mcu_fd_sc_mcu9t5v0__inv_1_1/ZN avdd 2.41473f
C392 acp vref 1.19231f
C393 amx acm 2.85701f
C394 vref vtemp 9.72394f
C395 avdd rv328_glue_0/rv328_glue_p0_0/gf180mcu_fd_sc_mcu9t5v0__nand2_1_6/a_245_69# 0
C396 rc_trim5 adc_refs0 0.04044f
C397 clk_lf avdd 1.42308f
C398 aco adc4 0.05164f
C399 rc_trim2 adc_mux0 0.04044f
C400 rc_trim0 ac_en 0.09104f
C401 adc_cmp xo_en 0.01896f
C402 adc_mux3 adc2 0.04044f
C403 aref clk_rc 0.17077f
C404 adc_dac5 aref 0.2369f
C405 bod_en rc_trim5 0.0882f
C406 vbp bg_en 0.24572f
C407 rc_trim1 rc_trim3 0.04216f
C408 adc_refs1 en_buf 0.04087f
C409 rv328_glue_0/rv328_glue_p0_0/gf180mcu_fd_sc_mcu9t5v0__inv_1_7/I bod_level1 1.01193f
C410 rv328_glue_0/rv328_glue_p0_0/gf180mcu_fd_sc_mcu9t5v0__nand2_1_4/ZN ac_en 0.92881f
C411 adc_mux3 adc_dac9 0.0452f
C412 bod_level2 bg_en 0.04266f
C413 adc_cmp amx 0.06636f
C414 rc_trim6 xo_en 0.04335f
C415 adc_mux1 adc7 0.04908f
C416 cmpa adc_mux0 0.08564f
C417 rc_trim2 ac_en 0.08344f
C418 adc_en adc7 0.04908f
C419 adc_cmp adc_sample 36.24353f
C420 ac_mux_en mux_en 0.139f
C421 rc_trim7 rc_trim0 0.04053f
C422 adc_refs0 clk_xa 0.05749f
C423 rc_trim1 adc_refs0 0.04044f
C424 mux_en rv328_glue_0/rv328_glue_p0_0/gf180mcu_fd_sc_mcu9t5v0__inv_1_8/I 0.01437f
C425 rv328_glue_0/rv328_glue_p0_0/gf180mcu_fd_sc_mcu9t5v0__nor2_1_1/ZN ac_en 1.93854f
C426 rv328_glue_0/rv328_glue_p0_0/gf180mcu_fd_sc_mcu9t5v0__nand2_1_5/a_245_69# bg_en 0.0162f
C427 adc_refs0 en_avcc 0.08534f
C428 bod_en clk_xa 0.10525f
C429 amx rc_trim6 0.05772f
C430 rc_trim1 bod_en 0.0882f
C431 adc_dac8 adc_mux0 0.04044f
C432 bod_en en_avcc 0.06937f
C433 avdd rv328_glue_0/rv328_glue_p0_0/gf180mcu_fd_sc_mcu9t5v0__inv_1_6/ZN 0.54988f
C434 adc_mux3 xo_en 0.04044f
C435 adc_dac4 ac_mux_en 0.04044f
C436 lv1 vref 0.09989f
C437 adc_dac5 adc_dac2 0.04144f
C438 ok adc_refs1 0.0452f
C439 cmpa ac_en 0.15656f
C440 rv328_glue_0/rv328_glue_p0_0/gf180mcu_fd_sc_mcu9t5v0__inv_1_4/I adc_en 1.05239f
C441 rc_trim5 adc_dac9 0.0452f
C442 rc_trim2 rc_trim7 0.04072f
C443 rv328_glue_0/rv328_glue_p0_0/gf180mcu_fd_sc_mcu9t5v0__nand3_1_1/a_271_69# adc_en 0.00139f
C444 ok rc_trim4 0.08971f
C445 rv328_glue_0/rv328_glue_p0_0/gf180mcu_fd_sc_mcu9t5v0__inv_1_2/I avdd 0.83707f
C446 ac_mux_en adc_dac6 0.04044f
C447 adc_en bg_en 0.10521f
C448 adc_mux3 amx 0.05667f
C449 adc_dac1 adc_mux0 0.04044f
C450 lv1 rv328_glue_0/rv328_glue_p0_0/gf180mcu_fd_sc_mcu9t5v0__inv_1_5/ZN 0
C451 smp ac_bg 0.09416f
C452 adc_mux3 adc_sample 0.04908f
C453 lv1 aref 0.13749f
C454 ac_mux_en xo_mode1 0.13028f
C455 adc_dac8 ac_en 0.04044f
C456 rv328_glue_0/rv328_glue_p0_0/gf180mcu_fd_sc_mcu9t5v0__nand2_1_4/ZN rv328_glue_0/rv328_glue_p0_0/gf180mcu_fd_sc_mcu9t5v0__inv_1_3/I 0
C457 adc_mux3 adc6 0.04044f
C458 ac_out ac_mux_en 4.19315f
C459 xo_mode1 rv328_glue_0/rv328_glue_p0_0/gf180mcu_fd_sc_mcu9t5v0__inv_1_8/I 0.38179f
C460 ac_out rv328_glue_0/rv328_glue_p0_0/gf180mcu_fd_sc_mcu9t5v0__inv_1_8/I 0.01437f
C461 rc_trim7 cmpa 0.0452f
C462 vbp bod_level0 0.04646f
C463 adc1 adc_mux3 0.04044f
C464 rv328_glue_0/rv328_glue_p0_0/gf180mcu_fd_sc_mcu9t5v0__inv_1_1/I en_avcc 0
C465 rc_trim5 xo_en 0.0287f
C466 rc_trim1 adc_dac9 0.0452f
C467 adc_dac9 clk_xa 0
C468 adc_dac1 ac_en 0.04044f
C469 bod_level2 bod_level0 0.04908f
C470 adc_refs0 rv328_glue_0/rv328_glue_p0_0/gf180mcu_fd_sc_mcu9t5v0__nor2_1_2/ZN 0.03978f
C471 vbp bod_level2 0.15049f
C472 ain1 ac_bg 0.10889f
C473 aco adc3 0.05164f
C474 adc5 avdd 0.4361f
C475 por_n bod_level0 0.04908f
C476 bod_en rv328_glue_0/rv328_glue_p0_0/gf180mcu_fd_sc_mcu9t5v0__nor2_1_2/ZN 1.25559f
C477 rc_trim7 adc_dac8 0.04044f
C478 rc_en adc_mux0 0.04548f
C479 amx rc_trim5 0.05772f
C480 mux_en adc_mux2 0.11279f
C481 vbp por_n 0.10155f
C482 aco adc_mux0 0.04044f
C483 rv328_glue_0/rv328_glue_p0_0/gf180mcu_fd_sc_mcu9t5v0__inv_1_3/I cmpa 0.02256f
C484 rc_trim7 adc_dac1 0.04044f
C485 ac_mux_en rv328_glue_0/rv328_glue_p0_0/gf180mcu_fd_sc_mcu9t5v0__nand2_1_7/ZN 0.02047f
C486 clk_xa xo_en 3.73515f
C487 rc_trim3 avdd 0.54574f
C488 rc_trim1 xo_en 0.01213f
C489 xo_mode0 bg_en 0.04056f
C490 rv328_glue_0/rv328_glue_p0_0/gf180mcu_fd_sc_mcu9t5v0__inv_1_8/I rv328_glue_0/rv328_glue_p0_0/gf180mcu_fd_sc_mcu9t5v0__nand2_1_7/ZN 1.66118f
C491 adc_dac4 adc_mux2 0.04044f
C492 en_avcc xo_en 0.02044f
C493 ac_bg bod_level1 0.043f
C494 rc_trim3 adc_dac0 0.04608f
C495 ac_en rc_en 0.09608f
C496 adc_cmp smp 0.10853f
C497 bod_en bod_o 5.48442f
C498 bod_level0 adc_mux1 0.04044f
C499 bod_level0 adc_en 0.04044f
C500 adc_dac6 adc_mux2 0.04044f
C501 ain1 acm 3.72437f
C502 amx clk_xa 0.05772f
C503 vbp adc_mux1 0.04646f
C504 rc_trim1 amx 0.05772f
C505 aco ac_en 0.22216f
C506 vbp adc_en 25.7027f
C507 vref mux_en 0.22179f
C508 adc_sample clk_xa 8.06313f
C509 adc_refs0 avdd 1.48539f
C510 adc0 avdd 0.76219f
C511 bod_level2 adc_mux1 0.04548f
C512 smp rc_trim6 0.04844f
C513 adc_mux2 xo_mode1 0.04179f
C514 adc_sample en_avcc 0.09598f
C515 ac_out adc_mux2 0.04179f
C516 adc_dac3 rc_trim3 0.04044f
C517 aref rv328_glue_0/rv328_glue_p0_0/gf180mcu_fd_sc_mcu9t5v0__inv_1_0/I 0.00187f
C518 bod_level2 adc_en 0.09494f
C519 adc_dac0 adc_refs0 0.04608f
C520 bod_en avdd 2.19608f
C521 mux_en rv328_glue_0/rv328_glue_p0_0/gf180mcu_fd_sc_mcu9t5v0__inv_1_5/ZN 0.19398f
C522 rv328_glue_0/rv328_glue_p0_0/gf180mcu_fd_sc_mcu9t5v0__inv_1_8/ZN rv328_glue_0/rv328_glue_p0_0/gf180mcu_fd_sc_mcu9t5v0__inv_1_8/I 1.30658f
C523 por_n adc_mux1 0.04044f
C524 rc_trim7 rc_en 0.04051f
C525 ac_bg adc_dac7 0.04179f
C526 rv328_glue_0/rv328_glue_p0_0/gf180mcu_fd_sc_mcu9t5v0__inv_1_6/ZN en_buf 0.00586f
C527 rv328_glue_0/rv328_glue_p0_0/gf180mcu_fd_sc_mcu9t5v0__nand2_1_4/ZN rv328_glue_0/rv328_glue_p0_0/gf180mcu_fd_sc_mcu9t5v0__nand2_1_4/a_245_69# 0.0162f
C528 aref mux_en 0.13622f
C529 adc_dac0 bod_en 0.04608f
C530 por_n adc_en 0.04044f
C531 adc7 adc_mux0 0.04908f
C532 vbp adc4 0.04646f
C533 lv1 rv328_glue_0/rv328_glue_p0_0/gf180mcu_fd_sc_mcu9t5v0__inv_1_7/I 1.51652f
C534 smp adc_mux3 0.09024f
C535 adc_dac3 adc_refs0 0.04044f
C536 ain0 avdd 1.41076f
C537 ac_mux_en rc_trim0 0.08848f
C538 adc_dac4 aref 0.2369f
C539 rv328_glue_0/rv328_glue_p0_0/gf180mcu_fd_sc_mcu9t5v0__nor2_1_2/ZN xo_en 0.168f
C540 adc_dac9 bod_o 0
C541 adc_dac3 bod_en 0.04044f
C542 vref xo_mode1 0.2101f
C543 ac_out vref 0.15514f
C544 rv328_glue_0/rv328_glue_p0_0/gf180mcu_fd_sc_mcu9t5v0__nand2_1_4/ZN ac_mux_en 0.50781f
C545 rv328_glue_0/rv328_glue_p0_0/gf180mcu_fd_sc_mcu9t5v0__inv_1_1/I avdd 0.54749f
C546 aref adc_dac6 0.2369f
C547 adc_en adc_mux1 0.04216f
C548 bod_level0 xo_mode0 0.04044f
C549 adc2 avdd 0.4361f
C550 adc_cmp bod_level1 0
C551 adc7 ac_en 0.04908f
C552 aco rv328_glue_0/rv328_glue_p0_0/gf180mcu_fd_sc_mcu9t5v0__inv_1_3/I 0.02082f
C553 rv328_glue_0/rv328_glue_p0_0/gf180mcu_fd_sc_mcu9t5v0__nor2_1_2/ZN rv328_glue_0/rv328_glue_p0_0/gf180mcu_fd_sc_mcu9t5v0__nor2_1_2/a_234_573# 0.02957f
C554 vbp xo_mode0 0.19191f
C555 rv328_glue_0/rv328_glue_p0_0/gf180mcu_fd_sc_mcu9t5v0__nor2_1_1/a_234_573# rv328_glue_0/rv328_glue_p0_0/gf180mcu_fd_sc_mcu9t5v0__inv_1_8/ZN 0.0014f
C556 rc_trim3 adc_refs1 0.0452f
C557 rc_trim2 ac_mux_en 0.08088f
C558 ac_out rv328_glue_0/rv328_glue_p0_0/gf180mcu_fd_sc_mcu9t5v0__inv_1_5/ZN 0.02315f
C559 aref xo_mode1 0.30286f
C560 adc_dac9 avdd 1.25287f
C561 adc_sample rv328_glue_0/rv328_glue_p0_0/gf180mcu_fd_sc_mcu9t5v0__nor2_1_2/ZN 0.03977f
C562 ac_out aref 0.13622f
C563 rc_trim3 rc_trim4 37.6965f
C564 ac_mux_en rv328_glue_0/rv328_glue_p0_0/gf180mcu_fd_sc_mcu9t5v0__nor2_1_1/ZN 0.01762f
C565 rv328_glue_0/rv328_glue_p0_0/gf180mcu_fd_sc_mcu9t5v0__inv_1_8/I rv328_glue_0/rv328_glue_p0_0/gf180mcu_fd_sc_mcu9t5v0__nor2_1_1/ZN 0
C566 bod_level2 xo_mode0 0.09413f
C567 adc_dac0 adc_dac9 0.04524f
C568 smp rc_trim5 0.04844f
C569 bod_level1 rc_trim6 0.04044f
C570 adc4 adc_mux1 0.04044f
C571 ac_bg clk_rc 0.04804f
C572 adc_dac5 ac_bg 0.04179f
C573 rv328_glue_0/rv328_glue_p0_0/gf180mcu_fd_sc_mcu9t5v0__inv_1_4/I ac_en 0.01955f
C574 adc_refs0 adc_refs1 75.17964f
C575 adc_dac4 adc_dac2 0.0426f
C576 adc_cmp adc_dac7 0.04548f
C577 ac_bg vtemp 0.05758f
C578 rc_trim4 adc_refs0 0.04044f
C579 adc4 adc_en 0.04044f
C580 acp ac_bg 1.28546f
C581 ac_mux_en cmpa 0.12618f
C582 amx bod_o 0.06276f
C583 cmpa rv328_glue_0/rv328_glue_p0_0/gf180mcu_fd_sc_mcu9t5v0__inv_1_8/I 0.01437f
C584 bod_en adc_refs1 49.6166f
C585 bg_en ac_en 0.13962f
C586 adc_dac3 adc_dac9 0.04544f
C587 bod_en rc_trim4 0.0882f
C588 adc_sample bod_o 16.0551f
C589 adc_mux3 bod_level1 0.04608f
C590 avdd xo_en 1.30393f
C591 adc_dac2 adc_dac6 0.041f
C592 adc_dac7 rc_trim6 0.04044f
C593 adc_dac0 xo_en 0.04608f
C594 ac_mux_en adc_dac8 0.04044f
C595 smp clk_xa 0.0536f
C596 smp rc_trim1 0.04844f
C597 adc_mux2 rc_trim0 0.04044f
C598 adc_dac2 xo_mode1 0.04179f
C599 aref rv328_glue_0/rv328_glue_p0_0/gf180mcu_fd_sc_mcu9t5v0__nand2_1_7/ZN 0.00198f
C600 amx avdd 2.04427f
C601 rv328_glue_0/rv328_glue_p0_0/gf180mcu_fd_sc_mcu9t5v0__nor2_1_2/a_234_573# avdd 0.02768f
C602 xo_mode0 adc_mux1 0.04044f
C603 ac_out adc_dac2 0.04683f
C604 rv328_glue_0/rv328_glue_p0_0/gf180mcu_fd_sc_mcu9t5v0__nor2_1_1/a_234_573# rv328_glue_0/rv328_glue_p0_0/gf180mcu_fd_sc_mcu9t5v0__nor2_1_1/ZN 0.02957f
C605 smp en_avcc 0.19432f
C606 rv328_glue_0/rv328_glue_p0_0/gf180mcu_fd_sc_mcu9t5v0__inv_1_4/I rv328_glue_0/rv328_glue_p0_0/gf180mcu_fd_sc_mcu9t5v0__nand3_1_1/a_455_69# 0.01168f
C607 adc_en xo_mode0 0.12132f
C608 adc_refs0 en_buf 0.15252f
C609 adc_sample avdd 1.92915f
C610 adc_dac0 amx 0.04709f
C611 rv328_glue_0/rv328_glue_p0_0/gf180mcu_fd_sc_mcu9t5v0__inv_1_7/I mux_en 0.01998f
C612 adc6 avdd 0.4361f
C613 adc_dac3 xo_en 0.04044f
C614 acp acm 11.52014f
C615 adc_mux3 adc_dac7 0.04044f
C616 ac_mux_en adc_dac1 0.04044f
C617 acm vtemp 0.10906f
C618 bod_en en_buf 0.04138f
C619 adc1 avdd 0.4361f
C620 vbp adc3 0.04646f
C621 ok rc_trim3 0.0898f
C622 rc_trim2 adc_mux2 0.04044f
C623 rc_trim5 bod_level1 0.04044f
C624 adc_dac3 amx 0.04709f
C625 bod_level0 adc_mux0 0.04044f
C626 rv328_glue_0/rv328_glue_p0_0/gf180mcu_fd_sc_mcu9t5v0__inv_1_3/I rv328_glue_0/rv328_glue_p0_0/gf180mcu_fd_sc_mcu9t5v0__inv_1_4/I 0.02438f
C627 adc_dac9 adc_refs1 0.0452f
C628 vbp adc_mux0 0.04646f
C629 adc_dac9 rc_trim4 0.0452f
C630 adc_cmp clk_rc 0.05881f
C631 adc_cmp adc_dac5 0.04548f
C632 vref rc_trim0 0.16003f
C633 rv328_glue_0/rv328_glue_p0_0/gf180mcu_fd_sc_mcu9t5v0__nor2_1_0/a_234_573# rv328_glue_0/rv328_glue_p0_0/gf180mcu_fd_sc_mcu9t5v0__nor2_1_1/ZN 0.00136f
C634 rv328_glue_0/rv328_glue_p0_0/gf180mcu_fd_sc_mcu9t5v0__nand2_1_1/a_245_69# avdd 0
C635 bod_level2 adc_mux0 0.04548f
C636 ok adc_refs0 0.04044f
C637 cmpa adc_mux2 0.08564f
C638 ac_mux_en rc_en 0.09352f
C639 adc_dac5 rc_trim6 0.04044f
C640 por_n adc_mux0 0.04044f
C641 bod_level0 ac_en 0.04044f
C642 aref rc_trim0 0.16664f
C643 rc_trim5 adc_dac7 0.04044f
C644 ok bod_en 0.16154f
C645 ac_out rv328_glue_0/rv328_glue_p0_0/gf180mcu_fd_sc_mcu9t5v0__inv_1_7/I 0.01992f
C646 smp rv328_glue_0/rv328_glue_p0_0/gf180mcu_fd_sc_mcu9t5v0__nor2_1_2/ZN 0.11704f
C647 rc_trim1 bod_level1 0.04044f
C648 vbp ac_en 0.78967f
C649 bod_level1 clk_xa 0.05749f
C650 aco ac_mux_en 0.09278f
C651 rc_trim2 vref 0.15243f
C652 aco rv328_glue_0/rv328_glue_p0_0/gf180mcu_fd_sc_mcu9t5v0__inv_1_8/I 0.01437f
C653 adc_refs1 xo_en 0.11402f
C654 rv328_glue_0/rv328_glue_p0_0/gf180mcu_fd_sc_mcu9t5v0__nand2_1_4/ZN rv328_glue_0/rv328_glue_p0_0/gf180mcu_fd_sc_mcu9t5v0__inv_1_5/ZN 0.11628f
C655 rc_trim4 xo_en 0.02144f
C656 rv328_glue_0/rv328_glue_p0_0/gf180mcu_fd_sc_mcu9t5v0__nand2_1_4/ZN aref 0.00187f
C657 bod_level1 en_avcc 0.10064f
C658 adc_dac8 adc_mux2 0.04044f
C659 bod_level2 ac_en 0.11645f
C660 adc3 adc_mux1 0.04044f
C661 adc3 adc_en 0.04044f
C662 amx adc_refs1 0.05772f
C663 adc_mux3 clk_rc 0.04548f
C664 adc_mux3 adc_dac5 0.04044f
C665 por_n ac_en 0.04044f
C666 rc_trim2 aref 0.13622f
C667 adc_mux3 vtemp 0.05581f
C668 amx rc_trim4 0.05772f
C669 rc_trim7 bod_level0 0.04044f
C670 acp adc_mux3 0
C671 adc_sample adc_refs1 5.68505f
C672 adc_mux1 adc_mux0 56.5956f
C673 vbp rc_trim7 0.13938f
C674 smp bod_o 0.09547f
C675 adc_en adc_mux0 46.2703f
C676 vref cmpa 0.15747f
C677 adc_dac1 adc_mux2 0.04044f
C678 aref rv328_glue_0/rv328_glue_p0_0/gf180mcu_fd_sc_mcu9t5v0__nor2_1_1/ZN 0.00198f
C679 rc_trim1 adc_dac7 0.04044f
C680 rv328_acsw_0/rv328_acsw_p0_0/gf180mcu_fd_sc_mcu9t5v0__inv_1_1/ZN ain0 0.381f
C681 en_buf xo_en 0.02074f
C682 bod_level2 rc_trim7 0.04695f
C683 lv1 adc_cmp 0.06813f
C684 adc_dac2 rc_trim0 0.04044f
C685 cmpa rv328_glue_0/rv328_glue_p0_0/gf180mcu_fd_sc_mcu9t5v0__inv_1_5/ZN 0.03495f
C686 adc_en rv328_glue_0/rv328_glue_p0_0/gf180mcu_fd_sc_mcu9t5v0__nand3_1_0/a_455_69# 0.00394f
C687 adc4 adc3 12.1306f
C688 aref cmpa 0.4376f
C689 smp avdd 4.26122f
C690 adc_mux1 ac_en 0.04088f
C691 adc_en ac_en 0.44563f
C692 adc_refs0 rv328_glue_0/rv328_glue_p0_0/gf180mcu_fd_sc_mcu9t5v0__inv_1_6/ZN 0.00914f
C693 adc_dac5 rc_trim5 0.04044f
C694 adc4 adc_mux0 0.04044f
C695 smp adc_dac0 0.04608f
C696 lv1 rc_trim6 0.08739f
C697 ac_mux_en adc7 0.04908f
C698 adc_sample en_buf 0.06508f
C699 bod_level1 rv328_glue_0/rv328_glue_p0_0/gf180mcu_fd_sc_mcu9t5v0__nor2_1_2/ZN 0.77483f
C700 ac_bg mux_en 0.10368f
C701 rc_trim2 adc_dac2 0.04044f
C702 adc_mux2 rc_en 0.04548f
C703 aref adc_dac8 0.2369f
C704 clk_lf adc_dac9 0
C705 rv328_glue_0/rv328_glue_p0_0/gf180mcu_fd_sc_mcu9t5v0__inv_1_2/I adc_refs0 0
C706 rv328_glue_0/rv328_glue_p0_0/gf180mcu_fd_sc_mcu9t5v0__inv_1_7/I rv328_glue_0/rv328_glue_p0_0/gf180mcu_fd_sc_mcu9t5v0__inv_1_8/ZN 0
C707 ok xo_en 0.10657f
C708 aco adc_mux2 0.04044f
C709 smp adc_dac3 0.04608f
C710 rc_trim7 adc_mux1 0.04044f
C711 ain1 avdd 1.41594f
C712 rc_trim7 adc_en 0.08088f
C713 adc4 ac_en 0.04044f
C714 adc_dac1 aref 0.2369f
C715 adc_dac4 ac_bg 0.04179f
C716 ac_mux_en rv328_glue_0/rv328_glue_p0_0/gf180mcu_fd_sc_mcu9t5v0__inv_1_4/I 0
C717 xo_mode0 adc_mux0 0.04044f
C718 rv328_glue_0/rv328_glue_p0_0/gf180mcu_fd_sc_mcu9t5v0__nand3_1_1/a_455_69# adc_en 0.00394f
C719 rc_trim1 clk_rc 0.01053f
C720 rc_trim1 adc_dac5 0.04044f
C721 cmpa adc_dac2 0.14152f
C722 clk_rc clk_xa 31.0284f
C723 ac_mux_en bg_en 0.10429f
C724 ac_bg adc_dac6 0.04179f
C725 xo_en rv328_glue_0/rv328_glue_p0_0/gf180mcu_fd_sc_mcu9t5v0__nand2_1_6/a_245_69# 0
C726 rv328_glue_0/rv328_glue_p0_0/gf180mcu_fd_sc_mcu9t5v0__inv_1_8/I bg_en 0.01437f
C727 ok adc_sample 0.0584f
C728 acm mux_en 0.04447f
C729 vref rc_en 0.16507f
C730 rv328_glue_0/rv328_glue_p0_0/gf180mcu_fd_sc_mcu9t5v0__nand2_1_4/ZN rv328_glue_0/rv328_glue_p0_0/gf180mcu_fd_sc_mcu9t5v0__inv_1_7/I 0
C731 ac_bg xo_mode1 0.04436f
C732 ac_out ac_bg 0.04436f
C733 amx rv328_acsw_0/rv328_acsw_p0_0/gf180mcu_fd_sc_mcu9t5v0__inv_1_1/ZN 0.0295f
C734 adc_dac2 adc_dac8 0.04069f
C735 bod_level1 avdd 1.22203f
C736 rv328_glue_0/rv328_glue_p0_0/gf180mcu_fd_sc_mcu9t5v0__inv_1_3/I adc_en 2.49803f
C737 aco vref 0.15243f
C738 clk_lf amx 0.06636f
C739 xo_mode0 ac_en 0.13257f
C740 rv328_glue_0/rv328_glue_p0_0/gf180mcu_fd_sc_mcu9t5v0__inv_1_2/I rv328_glue_0/rv328_glue_p0_0/gf180mcu_fd_sc_mcu9t5v0__inv_1_1/I 0.03746f
C741 adc_cmp rv328_glue_0/rv328_glue_p0_0/gf180mcu_fd_sc_mcu9t5v0__inv_1_0/I 0.04406f
C742 adc_dac7 bod_o 0
C743 clk_lf adc_sample 0
C744 adc_dac0 bod_level1 0.04608f
C745 lv1 rc_trim5 0.08739f
C746 aref rc_en 0.16664f
C747 aco rv328_glue_0/rv328_glue_p0_0/gf180mcu_fd_sc_mcu9t5v0__inv_1_5/ZN 0.01911f
C748 smp adc_refs1 0.08905f
C749 rv328_glue_0/rv328_glue_p0_0/gf180mcu_fd_sc_mcu9t5v0__inv_1_7/I rv328_glue_0/rv328_glue_p0_0/gf180mcu_fd_sc_mcu9t5v0__nor2_1_1/ZN 0.01551f
C750 adc_dac1 adc_dac2 40.8774f
C751 aco aref 0.13799f
C752 adc_cmp mux_en 0.05172f
C753 rc_trim3 adc_refs0 0.04044f
C754 smp rc_trim4 0.04844f
C755 adc_mux2 adc7 0.04908f
C756 rc_trim7 xo_mode0 0.00283f
C757 adc_dac3 bod_level1 0.04044f
C758 rc_trim3 bod_en 0.0882f
C759 adc_dac7 avdd 0.98727f
C760 rv328_glue_0/rv328_glue_p0_0/gf180mcu_fd_sc_mcu9t5v0__inv_1_7/I cmpa 0.0144f
C761 mux_en rc_trim6 0.08344f
C762 adc_cmp adc_dac4 0.04548f
C763 adc_dac0 adc_dac7 0.04062f
C764 lv1 clk_xa 0.10443f
C765 lv1 rc_trim1 0.08766f
C766 adc3 adc_mux0 0.04044f
C767 adc_cmp adc_dac6 0.04548f
C768 lv1 en_avcc 0.02189f
C769 bod_en adc_refs0 0.0603f
C770 smp en_buf 0.14449f
C771 avdd rv328_glue_0/rv328_glue_p0_0/gf180mcu_fd_sc_mcu9t5v0__nand2_1_7/a_245_69# 0
C772 rv328_glue_0/rv328_glue_p0_0/gf180mcu_fd_sc_mcu9t5v0__nand2_1_0/a_245_69# rv328_glue_0/rv328_glue_p0_0/gf180mcu_fd_sc_mcu9t5v0__inv_1_0/I 0.0162f
C773 adc_dac2 rc_en 0.04804f
C774 adc_dac4 rc_trim6 0.04044f
C775 ac_mux_en bod_level0 0.04044f
C776 adc_mux3 mux_en 43.3435f
C777 vref adc7 0.06117f
C778 adc_dac3 adc_dac7 0.041f
C779 vbp ac_mux_en 0.19525f
C780 aco adc_dac2 0.02842f
C781 adc_cmp ac_out 0.77532f
C782 rc_trim6 adc_dac6 0.04044f
C783 rv328_glue_0/rv328_glue_p0_0/gf180mcu_fd_sc_mcu9t5v0__inv_1_2/I adc_sample 1.34251f
C784 adc3 ac_en 0.04044f
C785 clk_rc bod_o 8.38958f
C786 adc_dac5 bod_o 0
C787 bod_level2 ac_mux_en 0.08613f
C788 bod_level2 rv328_glue_0/rv328_glue_p0_0/gf180mcu_fd_sc_mcu9t5v0__inv_1_8/I 0.01441f
C789 bod_level1 adc_refs1 0.04224f
C790 rc_trim6 xo_mode1 0
C791 rc_trim3 adc_dac9 0.0452f
C792 adc_mux3 adc_dac4 0.04044f
C793 ac_mux_en por_n 0.04044f
C794 ac_en adc_mux0 0.04122f
C795 bod_level1 rc_trim4 0.04044f
C796 smp ok 0.04939f
C797 adc_mux3 adc_dac6 0.04044f
C798 vref bg_en 0.09487f
C799 clk_rc avdd 2.02061f
C800 adc_dac5 avdd 0.99579f
C801 acp avdd 2.55254f
C802 avdd vtemp 0.43782f
C803 ac_bg rc_trim0 0.043f
C804 rv328_glue_0/rv328_glue_p0_0/gf180mcu_fd_sc_mcu9t5v0__inv_1_4/I rv328_glue_0/rv328_glue_p0_0/gf180mcu_fd_sc_mcu9t5v0__inv_1_5/ZN 0.40852f
C805 rc_trim5 mux_en 0.08351f
C806 adc_dac9 adc_refs0 0.0452f
C807 adc_dac0 adc_dac5 0.0408f
C808 adc_mux3 xo_mode1 0.04179f
C809 adc5 amx 0.05772f
C810 rv328_glue_0/rv328_glue_p0_0/gf180mcu_fd_sc_mcu9t5v0__inv_1_4/I aref 0.00334f
C811 lv1 rv328_glue_0/rv328_glue_p0_0/gf180mcu_fd_sc_mcu9t5v0__nor2_1_2/ZN 0.04318f
C812 rv328_glue_0/rv328_glue_p0_0/gf180mcu_fd_sc_mcu9t5v0__nand3_1_1/a_271_69# rv328_glue_0/rv328_glue_p0_0/gf180mcu_fd_sc_mcu9t5v0__inv_1_5/ZN 0
C813 ac_out adc_mux3 0.04179f
C814 adc_dac7 adc_refs1 0.04044f
C815 adc_cmp rv328_glue_0/rv328_glue_p0_0/gf180mcu_fd_sc_mcu9t5v0__nand2_1_7/ZN 0.02046f
C816 bod_en adc_dac9 0.0452f
C817 rc_trim3 xo_en 0.01711f
C818 rv328_glue_0/rv328_glue_p0_0/gf180mcu_fd_sc_mcu9t5v0__nand2_1_2/a_245_69# adc_en 0
C819 smp clk_lf 0.18204f
C820 aref bg_en 0.27432f
C821 rc_trim4 adc_dac7 0.04044f
C822 rc_trim7 adc_mux0 0.04044f
C823 adc5 adc6 12.1925f
C824 ac_mux_en adc_mux1 0.04122f
C825 bod_level1 en_buf 0.05903f
C826 ac_mux_en adc_en 0.11553p
C827 adc_dac4 rc_trim5 0.04044f
C828 aco rv328_glue_0/rv328_glue_p0_0/gf180mcu_fd_sc_mcu9t5v0__inv_1_7/I 0.01991f
C829 adc_en rv328_glue_0/rv328_glue_p0_0/gf180mcu_fd_sc_mcu9t5v0__inv_1_8/I 0.05953f
C830 rc_trim2 ac_bg 0.043f
C831 adc_dac3 adc_dac5 0.0426f
C832 rc_trim3 amx 0.05772f
C833 rc_trim5 adc_dac6 0.04044f
C834 bod_level0 adc_mux2 0.04044f
C835 mux_en clk_xa 0.10049f
C836 adc_refs0 xo_en 0.10925f
C837 rc_trim1 mux_en 0.08388f
C838 lv1 bod_o 0.01258f
C839 vbp adc_mux2 0.04646f
C840 ac_mux_en rv328_acsw_0/rv328_acsw_p0_0/gf180mcu_fd_sc_mcu9t5v0__inv_1_0/ZN 1.85332f
C841 ain1 rv328_acsw_0/rv328_acsw_p0_0/gf180mcu_fd_sc_mcu9t5v0__inv_1_1/ZN 0.02938f
C842 mux_en en_avcc 0.002f
C843 rc_trim7 ac_en 0.08344f
C844 bod_en xo_en 0.15718f
C845 rc_trim5 xo_mode1 0
C846 ac_mux_en adc4 0.04044f
C847 bod_level2 adc_mux2 0.04548f
C848 amx adc_refs0 0.06581f
C849 ac_bg cmpa 0.08955f
C850 rc_trim1 adc_dac4 0.04044f
C851 ok bod_level1 0.04951f
C852 amx adc0 0.05772f
C853 adc_sample adc_refs0 0.17067f
C854 lv1 avdd 1.82676f
C855 bod_en amx 0.05772f
C856 por_n adc_mux2 0.04044f
C857 rv328_glue_0/rv328_glue_p0_0/gf180mcu_fd_sc_mcu9t5v0__inv_1_3/I rv328_glue_0/rv328_glue_p0_0/gf180mcu_fd_sc_mcu9t5v0__nand3_1_0/a_455_69# 0.01168f
C858 smp rv328_glue_0/rv328_glue_p0_0/gf180mcu_fd_sc_mcu9t5v0__inv_1_6/ZN 0.02492f
C859 rc_trim1 adc_dac6 0.04044f
C860 adc_sample bod_en 0.10846f
C861 vref bod_level0 0.05254f
C862 clk_rc adc_refs1 0.05383f
C863 adc_dac5 adc_refs1 0.04044f
C864 adc1 adc0 12.0377f
C865 ac_bg adc_dac8 0.04179f
C866 rv328_glue_0/rv328_glue_p0_0/gf180mcu_fd_sc_mcu9t5v0__inv_1_3/I ac_en 0.02487f
C867 vbp vref 0.11635p
C868 smp rv328_glue_0/rv328_glue_p0_0/gf180mcu_fd_sc_mcu9t5v0__inv_1_2/I 1.25082f
C869 ac_mux_en xo_mode0 0.12132f
C870 adc_dac5 rc_trim4 0.04044f
C871 adc_cmp rv328_glue_0/rv328_glue_p0_0/gf180mcu_fd_sc_mcu9t5v0__nand2_1_4/ZN 0.02573f
C872 xo_mode1 clk_xa 0.06027f
C873 ac_out clk_xa 0.06045f
C874 amx ain0 0.10346f
C875 xo_mode0 rv328_glue_0/rv328_glue_p0_0/gf180mcu_fd_sc_mcu9t5v0__inv_1_8/I 0.00107f
C876 rc_trim6 rc_trim0 0.04063f
C877 en_avcc xo_mode1 0
C878 vref bod_level2 0.15747f
C879 ac_out en_avcc 0.07915f
C880 ac_bg adc_dac1 0.04179f
C881 adc_mux2 adc_mux1 56.4723f
C882 adc_dac9 xo_en 0.0452f
C883 vbp aref 19.3445f
C884 adc_en adc_mux2 0.04122f
C885 vref por_n 0.11371f
C886 adc_cmp rv328_glue_0/rv328_glue_p0_0/gf180mcu_fd_sc_mcu9t5v0__nor2_1_1/ZN 0.01761f
C887 mux_en rv328_glue_0/rv328_glue_p0_0/gf180mcu_fd_sc_mcu9t5v0__nor2_1_2/ZN 0.04215f
C888 adc2 amx 0.05772f
C889 adc_sample rv328_glue_0/rv328_glue_p0_0/gf180mcu_fd_sc_mcu9t5v0__inv_1_1/I 0.17484f
C890 bod_level2 aref 0.13622f
C891 clk_lf adc_dac7 0
C892 adc_mux3 rc_trim0 0.04044f
C893 rc_trim2 rc_trim6 0.04088f
C894 amx adc_dac9 0.05845f
C895 adc_sample adc_dac9 0.63495f
C896 rv328_glue_0/rv328_glue_p0_0/gf180mcu_fd_sc_mcu9t5v0__inv_1_7/I bg_en 0.03736f
C897 adc_cmp cmpa 0.12776f
C898 adc1 adc2 12.0687f
C899 adc4 adc_mux2 0.04044f
C900 bod_level1 rv328_glue_0/rv328_glue_p0_0/gf180mcu_fd_sc_mcu9t5v0__inv_1_6/ZN 0
C901 mux_en bod_o 0.04804f
C902 vref adc_mux1 0.05168f
C903 ac_bg rc_en 0.04804f
C904 vref adc_en 0.16863f
C905 en_avcc rv328_glue_0/rv328_glue_p0_0/gf180mcu_fd_sc_mcu9t5v0__nand2_1_7/ZN 0.02051f
C906 adc_mux3 rc_trim2 0.04044f
C907 rv328_glue_0/rv328_glue_p0_0/gf180mcu_fd_sc_mcu9t5v0__inv_1_1/I rv328_glue_0/rv328_glue_p0_0/gf180mcu_fd_sc_mcu9t5v0__nand2_1_1/a_245_69# 0.0162f
C908 adc_dac2 bod_level0 0.04044f
C909 cmpa rc_trim6 0.0452f
C910 lv1 adc_refs1 0.05984f
C911 smp rc_trim3 0.04844f
C912 aco ac_bg 0.043f
C913 adc_cmp adc_dac8 0.04548f
C914 vbp adc_dac2 0.04613f
C915 rv328_glue_0/rv328_glue_p0_0/gf180mcu_fd_sc_mcu9t5v0__nor2_1_2/ZN xo_mode1 0
C916 rv328_glue_0/rv328_glue_p0_0/gf180mcu_fd_sc_mcu9t5v0__inv_1_0/I avdd 0.72353f
C917 lv1 rc_trim4 0.08745f
C918 amx xo_en 0.05772f
C919 ac_out rv328_glue_0/rv328_glue_p0_0/gf180mcu_fd_sc_mcu9t5v0__nor2_1_2/ZN 0.0345f
C920 adc_en rv328_glue_0/rv328_glue_p0_0/gf180mcu_fd_sc_mcu9t5v0__inv_1_5/ZN 0.15289f
C921 adc_sample xo_en 0.01997f
C922 ac_mux_en adc3 0.04044f
C923 rc_trim5 rc_trim0 0.04072f
C924 ok clk_rc 0.10748f
C925 aref adc_en 0.44209f
C926 mux_en avdd 33.80637f
C927 bod_level2 adc_dac2 0.04804f
C928 vref rv328_acsw_0/rv328_acsw_p0_0/gf180mcu_fd_sc_mcu9t5v0__inv_1_0/ZN 0.04776f
C929 adc_cmp adc_dac1 0.04548f
C930 adc_mux2 xo_mode0 0.04044f
C931 adc_dac8 rc_trim6 0.04044f
C932 adc_mux3 cmpa 0.08564f
C933 rv328_glue_0/rv328_glue_p0_0/gf180mcu_fd_sc_mcu9t5v0__nand2_1_4/a_245_69# ac_en 0
C934 bod_o adc_dac6 0
C935 vref adc4 0.05254f
C936 ac_mux_en adc_mux0 0.04216f
C937 smp adc_refs0 0.12919f
C938 adc_sample amx 0.06636f
C939 rv328_glue_0/rv328_glue_p0_0/gf180mcu_fd_sc_mcu9t5v0__inv_1_8/ZN en_avcc 0
C940 amx adc6 0.05772f
C941 adc_dac4 avdd 0.99714f
C942 acp rv328_acsw_0/rv328_acsw_p0_0/gf180mcu_fd_sc_mcu9t5v0__inv_1_1/ZN 0.99946f
C943 smp bod_en 0.13851f
C944 clk_lf clk_rc 0.62672f
C945 adc_dac1 rc_trim6 0.04044f
C946 lv1 en_buf 6.17452f
C947 adc1 amx 0.05772f
C948 rc_trim2 rc_trim5 0.04122f
C949 adc_dac0 adc_dac4 0.041f
C950 adc_dac6 avdd 0.98728f
C951 adc_mux3 adc_dac8 0.04044f
C952 rc_trim1 rc_trim0 38.0099f
C953 rv328_glue_0/rv328_glue_p0_0/gf180mcu_fd_sc_mcu9t5v0__nor2_1_2/ZN rv328_glue_0/rv328_glue_p0_0/gf180mcu_fd_sc_mcu9t5v0__nand2_1_7/ZN 0
C954 ac_mux_en ac_en 0.12p
C955 adc_dac0 adc_dac6 0.04069f
C956 vref xo_mode0 0.19979f
C957 rv328_glue_0/rv328_glue_p0_0/gf180mcu_fd_sc_mcu9t5v0__inv_1_8/I ac_en 0.01452f
C958 adc_dac2 adc_mux1 0.04044f
C959 avdd xo_mode1 57.99942f
C960 ac_bg adc7 0.05164f
C961 adc_dac2 adc_en 0.0913f
C962 ac_out avdd 52.98794f
C963 adc_mux3 adc_dac1 0.04044f
C964 adc_dac3 adc_dac4 41.2562f
C965 rc_trim5 cmpa 0.0452f
C966 rc_trim3 bod_level1 0.04044f
C967 adc_dac0 xo_mode1 0.04743f
C968 rv328_glue_0/rv328_glue_p0_0/gf180mcu_fd_sc_mcu9t5v0__nand2_1_4/ZN en_avcc 0.02507f
C969 adc_cmp aco 72.26033f
C970 ac_out adc_dac0 0.05247f
C971 bod_level2 rv328_glue_0/rv328_glue_p0_0/gf180mcu_fd_sc_mcu9t5v0__inv_1_7/I 1.98739f
C972 smp rv328_glue_0/rv328_glue_p0_0/gf180mcu_fd_sc_mcu9t5v0__inv_1_1/I 0.02188f
C973 rc_trim1 rc_trim2 37.9054f
C974 aref xo_mode0 0.27245f
C975 rc_trim6 rc_en 0.04053f
C976 adc_dac3 adc_dac6 0.04144f
C977 lv1 ok 43.6412f
C978 rc_trim7 ac_mux_en 0.08088f
C979 smp adc_dac9 0.25182f
C980 rc_trim5 adc_dac8 0.04044f
C981 en_avcc rv328_glue_0/rv328_glue_p0_0/gf180mcu_fd_sc_mcu9t5v0__nor2_1_1/ZN 0.02042f
C982 adc_dac3 xo_mode1 0.04179f
C983 ain1 ain0 12.74582f
C984 rv328_glue_0/rv328_glue_p0_0/gf180mcu_fd_sc_mcu9t5v0__inv_1_8/ZN rv328_glue_0/rv328_glue_p0_0/gf180mcu_fd_sc_mcu9t5v0__nor2_1_2/ZN 0.27064f
C985 adc_dac3 ac_out 0.04683f
C986 adc3 adc_mux2 0.04044f
C987 bod_level1 adc_refs0 0.04154f
C988 mux_en adc_refs1 0.04079f
C989 rc_trim3 adc_dac7 0.04044f
C990 cmpa clk_xa 45.7133f
C991 rc_trim1 cmpa 0.0452f
C992 rc_trim4 mux_en 0.08353f
C993 bod_en bod_level1 50.35733f
C994 adc_mux2 adc_mux0 0.04216f
C995 adc_dac1 rc_trim5 0.04044f
C996 adc_mux3 rc_en 0.04548f
C997 cmpa en_avcc 7.31367f
C998 avdd rv328_glue_0/rv328_glue_p0_0/gf180mcu_fd_sc_mcu9t5v0__nand2_1_7/ZN 0.5028f
C999 aco adc_mux3 0.04044f
C1000 aco rv328_glue_0/rv328_glue_p0_0/gf180mcu_fd_sc_mcu9t5v0__nand2_1_0/a_245_69# 0
C1001 adc_dac4 adc_refs1 0.04044f
C1002 rv328_glue_0/rv328_glue_p0_0/gf180mcu_fd_sc_mcu9t5v0__inv_1_7/I adc_en 0.02008f
C1003 adc_dac4 rc_trim4 0.04044f
C1004 smp xo_en 6.54965f
C1005 adc_dac8 clk_xa 0
C1006 adc_dac2 xo_mode0 0.04044f
C1007 rc_trim1 adc_dac8 0.04044f
C1008 adc_refs0 adc_dac7 0.04044f
C1009 rv328_glue_0/rv328_glue_p0_0/gf180mcu_fd_sc_mcu9t5v0__nand2_1_4/ZN rv328_glue_0/rv328_glue_p0_0/gf180mcu_fd_sc_mcu9t5v0__nor2_1_2/ZN 0
C1010 adc_dac6 adc_refs1 0.04044f
C1011 bod_en adc_dac7 0.04044f
C1012 adc_mux2 ac_en 0.04072f
C1013 vref adc3 0.05254f
C1014 rc_trim4 adc_dac6 0.04044f
C1015 mux_en en_buf 0.35672f
C1016 smp amx 0.12888f
C1017 rc_trim1 adc_dac1 0.04044f
C1018 adc_refs1 xo_mode1 0.09331f
C1019 ac_out adc_refs1 0.04573f
C1020 smp adc_sample 0.11018f
C1021 rv328_glue_0/rv328_glue_p0_0/gf180mcu_fd_sc_mcu9t5v0__nand3_1_0/a_271_69# adc_en 0.00139f
C1022 rc_trim5 rc_en 0.04063f
C1023 vref adc_mux0 0.05168f
C1024 rv328_glue_0/rv328_glue_p0_0/gf180mcu_fd_sc_mcu9t5v0__inv_1_8/ZN avdd 0.50186f
C1025 rv328_glue_0/rv328_glue_p0_0/gf180mcu_fd_sc_mcu9t5v0__nor2_1_2/ZN rv328_glue_0/rv328_glue_p0_0/gf180mcu_fd_sc_mcu9t5v0__nor2_1_1/ZN 0.70612f
C1026 adc5 vtemp 0.00593f
C1027 rc_trim4 xo_mode1 0
C1028 bod_level1 adc_dac9 0.0452f
C1029 adc_cmp rv328_glue_0/rv328_glue_p0_0/gf180mcu_fd_sc_mcu9t5v0__inv_1_4/I 0.01437f
C1030 rc_trim7 adc_mux2 0.04044f
C1031 cmpa rv328_glue_0/rv328_glue_p0_0/gf180mcu_fd_sc_mcu9t5v0__nor2_1_2/ZN 0.04215f
C1032 rc_trim3 adc_dac5 0.04044f
C1033 avdd rc_trim0 0.54558f
C1034 adc_cmp bg_en 0.0154f
C1035 ain1 amx 11.20931f
C1036 ok mux_en 49.8801f
C1037 vref ac_en 0.17195f
C1038 adc_mux3 adc7 0.04908f
C1039 rv328_glue_0/rv328_glue_p0_0/gf180mcu_fd_sc_mcu9t5v0__nand3_1_0/a_455_69# rv328_glue_0/rv328_glue_p0_0/gf180mcu_fd_sc_mcu9t5v0__inv_1_5/ZN 0
C1040 ac_bg bod_level0 0.043f
C1041 adc_dac0 rc_trim0 0.04608f
C1042 smp rv328_glue_0/rv328_glue_p0_0/gf180mcu_fd_sc_mcu9t5v0__nand2_1_1/a_245_69# 0
C1043 en_buf xo_mode1 0
C1044 rv328_glue_0/rv328_glue_p0_0/gf180mcu_fd_sc_mcu9t5v0__nand2_1_4/ZN avdd 0.48996f
C1045 vbp ac_bg 0.05487f
C1046 rc_trim1 rc_en 0.0534f
C1047 ac_out en_buf 0.0578f
C1048 adc_dac9 adc_dac7 0.04736f
C1049 bod_level1 xo_en 0.10938f
C1050 rv328_glue_0/rv328_glue_p0_0/gf180mcu_fd_sc_mcu9t5v0__inv_1_5/ZN ac_en 0.02469f
C1051 clk_rc adc_refs0 0.04908f
C1052 adc_dac5 adc_refs0 0.04044f
C1053 adc_refs1 rv328_glue_0/rv328_glue_p0_0/gf180mcu_fd_sc_mcu9t5v0__nand2_1_7/ZN 0.02045f
C1054 aco clk_xa 0.10963f
C1055 aref ac_en 0.17451f
C1056 bod_level2 ac_bg 0.04804f
C1057 rc_trim2 avdd 0.54558f
C1058 bod_en clk_rc 0.1036f
C1059 adc_dac5 bod_en 0.04044f
C1060 cmpa bod_o 0.10576f
C1061 adc_dac3 rc_trim0 0.04044f
C1062 clk_lf mux_en 0.06027f
C1063 aco en_avcc 0.06649f
C1064 adc0 vtemp 9.15703f
C1065 avdd rv328_glue_0/rv328_glue_p0_0/gf180mcu_fd_sc_mcu9t5v0__nor2_1_1/ZN 0.45603f
C1066 amx bod_level1 0.05772f
C1067 ac_bg por_n 0.043f
C1068 adc_dac0 rc_trim2 0.04608f
C1069 vref rc_trim7 0.15243f
C1070 ac_mux_en rv328_glue_0/rv328_glue_p0_0/gf180mcu_fd_sc_mcu9t5v0__nand2_1_4/a_245_69# 0
C1071 adc_dac2 adc_mux0 0.04044f
C1072 adc_sample bod_level1 0.06417f
C1073 adc_dac7 xo_en 0.04044f
C1074 ok xo_mode1 0.10712f
C1075 adc_dac8 bod_o 0
C1076 vbp acm 4.46969f
C1077 rv328_glue_0/rv328_glue_p0_0/gf180mcu_fd_sc_mcu9t5v0__nand3_1_1/a_455_69# rv328_glue_0/rv328_glue_p0_0/gf180mcu_fd_sc_mcu9t5v0__inv_1_5/ZN 0
C1078 cmpa avdd 2.58987f
C1079 ok ac_out 0.04436f
C1080 rc_trim7 aref 0.13622f
C1081 adc_dac3 rc_trim2 0.04044f
C1082 acp ain0 2.54803f
C1083 ain0 vtemp 0.05149f
C1084 en_buf rv328_glue_0/rv328_glue_p0_0/gf180mcu_fd_sc_mcu9t5v0__nand2_1_7/ZN 0.02053f
C1085 adc_dac0 cmpa 11.4831f
C1086 lv1 rc_trim3 0.08748f
C1087 clk_lf adc_dac6 0
C1088 amx adc_dac7 0.04709f
C1089 vref rv328_glue_0/rv328_glue_p0_0/gf180mcu_fd_sc_mcu9t5v0__inv_1_3/I 0
C1090 ac_bg adc_mux1 0.04328f
C1091 adc_dac2 ac_en 0.04044f
C1092 ac_bg adc_en 0.13554f
C1093 ac_mux_en rv328_glue_0/rv328_glue_p0_0/gf180mcu_fd_sc_mcu9t5v0__inv_1_8/I 0.01437f
C1094 adc_dac8 avdd 0.98727f
C1095 adc_sample adc_dac7 0.02065f
C1096 adc_cmp bod_level0 0.04908f
C1097 mux_en rv328_glue_0/rv328_glue_p0_0/gf180mcu_fd_sc_mcu9t5v0__inv_1_6/ZN 1.29474f
C1098 adc_refs1 rc_trim0 0.0528f
C1099 adc2 vtemp 0.01169f
C1100 adc_cmp vbp 0.16273f
C1101 rv328_glue_0/rv328_glue_p0_0/gf180mcu_fd_sc_mcu9t5v0__inv_1_3/I rv328_glue_0/rv328_glue_p0_0/gf180mcu_fd_sc_mcu9t5v0__inv_1_5/ZN 0.78861f
C1102 adc_dac3 cmpa 0.13281f
C1103 adc_dac0 adc_dac8 0.04058f
C1104 adc_dac9 clk_rc 0
C1105 adc_dac5 adc_dac9 0.04576f
C1106 rc_trim4 rc_trim0 0.04088f
C1107 rv328_glue_0/rv328_glue_p0_0/gf180mcu_fd_sc_mcu9t5v0__inv_1_3/I aref 0.00202f
C1108 aco rv328_glue_0/rv328_glue_p0_0/gf180mcu_fd_sc_mcu9t5v0__nor2_1_2/ZN 0.03449f
C1109 rv328_glue_0/rv328_glue_p0_0/gf180mcu_fd_sc_mcu9t5v0__inv_1_2/I rv328_glue_0/rv328_glue_p0_0/gf180mcu_fd_sc_mcu9t5v0__inv_1_0/I 0
C1110 xtal2 xtal1 2.94074f
C1111 lv1 adc_refs0 0.05973f
C1112 ac_bg rv328_acsw_0/rv328_acsw_p0_0/gf180mcu_fd_sc_mcu9t5v0__inv_1_0/ZN 0
C1113 adc_dac1 avdd 1.00584f
C1114 adc_cmp bod_level2 0
C1115 bod_level0 rc_trim6 0.04044f
C1116 rv328_glue_0/rv328_glue_p0_0/gf180mcu_fd_sc_mcu9t5v0__inv_1_8/ZN en_buf 0
C1117 rv328_glue_0/rv328_glue_p0_0/gf180mcu_fd_sc_mcu9t5v0__nand2_1_4/ZN adc_refs1 0.16738f
C1118 lv1 bod_en 0.14034f
C1119 vbp rc_trim6 0.13938f
C1120 ac_bg adc4 0.043f
C1121 adc_dac0 adc_dac1 40.6881f
C1122 rc_trim7 adc_dac2 0.04044f
C1123 adc_dac3 adc_dac8 0.0408f
C1124 rc_trim2 adc_refs1 0.0452f
C1125 acm adc_mux1 0
C1126 bod_level2 rc_trim6 0.04695f
C1127 acm adc_en 0
C1128 rc_trim2 rc_trim4 0.04216f
C1129 adc_refs1 rv328_glue_0/rv328_glue_p0_0/gf180mcu_fd_sc_mcu9t5v0__nor2_1_1/ZN 0.0176f
C1130 clk_rc xo_en 0.06635f
C1131 adc_dac5 xo_en 0.04044f
C1132 rv328_glue_0/rv328_glue_p0_0/gf180mcu_fd_sc_mcu9t5v0__inv_1_4/I en_avcc 0.0458f
C1133 aco bod_o 0.05668f
C1134 rv328_glue_0/rv328_glue_p0_0/gf180mcu_fd_sc_mcu9t5v0__nand2_1_7/ZN rv328_glue_0/rv328_glue_p0_0/gf180mcu_fd_sc_mcu9t5v0__nand2_1_6/a_245_69# 0
C1135 adc_mux3 bod_level0 0.04608f
C1136 adc_dac3 adc_dac1 0.0426f
C1137 vbp adc_mux3 0.04646f
C1138 en_avcc bg_en 0.0621f
C1139 rv328_glue_0/rv328_glue_p0_0/gf180mcu_fd_sc_mcu9t5v0__inv_1_7/I ac_en 0.02791f
C1140 acm rv328_acsw_0/rv328_acsw_p0_0/gf180mcu_fd_sc_mcu9t5v0__inv_1_0/ZN 1.44567f
C1141 rv328_glue_0/rv328_glue_p0_0/gf180mcu_fd_sc_mcu9t5v0__nand2_1_4/ZN en_buf 0.02932f
C1142 ac_bg xo_mode0 0.043f
C1143 amx clk_rc 0.06276f
C1144 adc_dac5 amx 0.04709f
C1145 avdd rc_en 0.65963f
C1146 cmpa adc_refs1 0.08624f
C1147 adc5 mux_en 0.043f
C1148 adc_cmp adc_mux1 0.04908f
C1149 acp amx 0.15156f
C1150 adc_mux3 bod_level2 0.05111f
C1151 adc_sample clk_rc 7.36912f
C1152 adc_sample adc_dac5 0.01258f
C1153 amx vtemp 0.36475f
C1154 rc_trim4 cmpa 0.0452f
C1155 adc_dac0 rc_en 0.05368f
C1156 adc_cmp adc_en 6.18453f
C1157 aco avdd 33.75859f
C1158 ac_out rv328_glue_0/rv328_glue_p0_0/gf180mcu_fd_sc_mcu9t5v0__inv_1_2/I 0.019f
C1159 ac_mux_en adc_mux2 0.04088f
C1160 adc_mux3 por_n 0.04044f
C1161 aco adc_dac0 0.18722f
C1162 smp bod_level1 0.11648f
C1163 en_buf rv328_glue_0/rv328_glue_p0_0/gf180mcu_fd_sc_mcu9t5v0__nor2_1_1/ZN 0.02043f
C1164 rc_trim6 adc_mux1 0.04044f
C1165 adc_dac8 adc_refs1 0.04044f
C1166 adc1 vtemp 0.01729f
C1167 rc_trim6 adc_en 0.08088f
C1168 ok rc_trim0 0.09885f
C1169 rc_trim3 mux_en 0.08363f
C1170 rc_trim4 adc_dac8 0.04044f
C1171 rc_trim5 bod_level0 0.04044f
C1172 adc_dac3 rc_en 0.04804f
C1173 vbp rc_trim5 0.13938f
C1174 adc_dac3 aco 0.02128f
C1175 cmpa en_buf 0.09523f
C1176 adc_dac1 adc_refs1 0.04044f
C1177 bod_level2 rc_trim5 0.04695f
C1178 adc_dac1 rc_trim4 0.04044f
C1179 adc_mux3 adc_mux1 0.04216f
C1180 rc_trim3 adc_dac4 0.04044f
C1181 smp adc_dac7 0.04625f
C1182 lv1 xo_en 0.16381f
C1183 adc_mux3 adc_en 0.04088f
C1184 adc_refs0 mux_en 0.0409f
C1185 rv328_glue_0/rv328_glue_p0_0/gf180mcu_fd_sc_mcu9t5v0__nor2_1_2/ZN bg_en 1.41365f
C1186 ok rc_trim2 0.08996f
C1187 mux_en adc0 0.05109f
C1188 vref ac_mux_en 0.84347f
C1189 rc_trim3 adc_dac6 0.04044f
C1190 bod_en mux_en 0.08407f
C1191 bod_level0 clk_xa 0.04044f
C1192 rc_trim1 bod_level0 0.04044f
C1193 ac_mux_en rv328_glue_0/rv328_glue_p0_0/gf180mcu_fd_sc_mcu9t5v0__inv_1_5/ZN 0
C1194 avdd adc7 0.56564f
C1195 vbp clk_xa 0.15642f
C1196 vbp rc_trim1 0.13938f
C1197 adc_dac4 adc_refs0 0.04044f
C1198 rc_trim3 xo_mode1 0
C1199 ac_mux_en aref 0.1382f
C1200 lv1 adc_sample 0.08309f
C1201 aref rv328_glue_0/rv328_glue_p0_0/gf180mcu_fd_sc_mcu9t5v0__inv_1_8/I 0.00187f
C1202 ac_bg adc3 0.043f
C1203 vbp en_avcc 13.7263f
C1204 bod_en adc_dac4 0.04044f
C1205 ok cmpa 0.04804f
C1206 adc_refs0 adc_dac6 0.04044f
C1207 adc_refs1 rc_en 0.0528f
C1208 bod_level2 clk_xa 0.064f
C1209 adc_mux3 adc4 0.04044f
C1210 rc_trim1 bod_level2 0.04708f
C1211 mux_en ain0 0.3123f
C1212 rv328_glue_0/rv328_glue_p0_0/gf180mcu_fd_sc_mcu9t5v0__inv_1_3/I rv328_glue_0/rv328_glue_p0_0/gf180mcu_fd_sc_mcu9t5v0__nand3_1_0/a_271_69# 0.00232f
C1213 rc_trim4 rc_en 0.04072f
C1214 rv328_glue_0/rv328_glue_p0_0/gf180mcu_fd_sc_mcu9t5v0__inv_1_1/I rv328_glue_0/rv328_glue_p0_0/gf180mcu_fd_sc_mcu9t5v0__inv_1_0/I 0.06074f
C1215 rc_trim6 xo_mode0 0.00128f
C1216 ac_bg adc_mux0 0.04344f
C1217 bod_level2 en_avcc 0.24366f
C1218 rc_trim5 adc_mux1 0.04044f
C1219 por_n clk_xa 0.26702f
C1220 bod_en adc_dac6 0.04044f
C1221 aco adc_refs1 0.03795f
C1222 rc_trim5 adc_en 0.08088f
C1223 adc_refs0 xo_mode1 0.08848f
C1224 rv328_glue_0/rv328_glue_p0_0/gf180mcu_fd_sc_mcu9t5v0__inv_1_4/I avdd 0.78789f
C1225 ac_out adc_refs0 0.02713f
C1226 rv328_glue_0/rv328_glue_p0_0/gf180mcu_fd_sc_mcu9t5v0__nand3_1_1/a_271_69# avdd 0
C1227 clk_lf cmpa 0.34652f
C1228 adc2 mux_en 0.043f
C1229 bod_en xo_mode1 0.13772f
C1230 avdd bg_en 0.42137f
C1231 ac_out bod_en 0.06193f
C1232 adc_mux3 xo_mode0 0.04044f
C1233 rv328_glue_0/rv328_glue_p0_0/gf180mcu_fd_sc_mcu9t5v0__nand2_1_4/ZN rv328_glue_0/rv328_glue_p0_0/gf180mcu_fd_sc_mcu9t5v0__inv_1_6/ZN 0.52309f
C1234 smp clk_rc 0.04724f
C1235 smp adc_dac5 0.04616f
C1236 bod_level1 adc_dac7 0.04044f
C1237 ac_bg ac_en 47.8053f
C1238 ac_mux_en adc_dac2 0.04044f
C1239 clk_xa adc_mux1 0.04044f
C1240 clk_lf adc_dac8 0
C1241 adc_en clk_xa 0.09793f
C1242 rc_trim1 adc_mux1 0.04044f
C1243 acm adc_mux0 0
C1244 aco en_buf 0.04918f
C1245 rc_trim1 adc_en 0.08088f
C1246 vref adc_mux2 0.05168f
C1247 adc_dac4 adc_dac9 0.04555f
C1248 adc_en en_avcc 0.12979f
C1249 rv328_glue_0/rv328_glue_p0_0/gf180mcu_fd_sc_mcu9t5v0__nand2_1_3/a_245_69# avdd 0
C1250 adc_dac9 adc_dac6 0.0462f
C1251 adc_refs0 rv328_glue_0/rv328_glue_p0_0/gf180mcu_fd_sc_mcu9t5v0__nand2_1_7/ZN 0.02045f
C1252 mux_en xo_en 0.16308f
C1253 rc_trim7 ac_bg 0.043f
C1254 bod_level2 rv328_glue_0/rv328_glue_p0_0/gf180mcu_fd_sc_mcu9t5v0__nor2_1_2/ZN 0.04295f
C1255 ac_out rv328_glue_0/rv328_glue_p0_0/gf180mcu_fd_sc_mcu9t5v0__inv_1_1/I 0.52824f
C1256 ain1 acp 0.14652f
C1257 ain1 vtemp 0.05653f
C1258 bod_en rv328_glue_0/rv328_glue_p0_0/gf180mcu_fd_sc_mcu9t5v0__nand2_1_7/ZN 0.02046f
C1259 acm ac_en 0.05101f
C1260 rc_trim5 xo_mode0 0
C1261 adc_cmp adc_mux0 0.04908f
C1262 adc_sample rv328_glue_0/rv328_glue_p0_0/gf180mcu_fd_sc_mcu9t5v0__inv_1_0/I 0
C1263 adc_dac9 xo_mode1 0.04655f
C1264 ac_out adc_dac9 0.05159f
C1265 ok rc_en 18.7308f
C1266 amx mux_en 0.13541f
C1267 bod_level0 bod_o 1.03143f
C1268 rv328_glue_0/rv328_glue_p0_0/gf180mcu_fd_sc_mcu9t5v0__nor2_1_2/ZN rv328_glue_0/rv328_glue_p0_0/gf180mcu_fd_sc_mcu9t5v0__nand2_1_5/a_245_69# 0
C1269 adc_dac4 xo_en 0.04044f
C1270 ok aco 0.043f
C1271 vbp bod_o 0.0515f
C1272 adc_sample mux_en 0.05182f
C1273 rv328_glue_0/rv328_glue_p0_0/gf180mcu_fd_sc_mcu9t5v0__inv_1_2/I cmpa 0.04251f
C1274 mux_en adc6 0.043f
C1275 rc_trim6 adc_mux0 0.04044f
C1276 adc_dac6 xo_en 0.04044f
C1277 ac_mux_en rv328_glue_0/rv328_glue_p0_0/gf180mcu_fd_sc_mcu9t5v0__inv_1_7/I 0.0236f
C1278 rv328_glue_0/rv328_glue_p0_0/gf180mcu_fd_sc_mcu9t5v0__inv_1_4/I adc_refs1 0.96036f
C1279 adc1 mux_en 0.043f
C1280 rc_trim3 rc_trim0 0.04122f
C1281 lv1 smp 0.09704f
C1282 rv328_glue_0/rv328_glue_p0_0/gf180mcu_fd_sc_mcu9t5v0__inv_1_7/I rv328_glue_0/rv328_glue_p0_0/gf180mcu_fd_sc_mcu9t5v0__inv_1_8/I 0
C1283 amx adc_dac4 0.04709f
C1284 bod_level1 clk_rc 0.04908f
C1285 adc_dac5 bod_level1 0.04044f
C1286 rv328_glue_0/rv328_glue_p0_0/gf180mcu_fd_sc_mcu9t5v0__nand3_1_1/a_271_69# adc_refs1 0.00297f
C1287 bod_level0 avdd 1.32423f
C1288 adc_cmp ac_en 0.32647f
C1289 adc_mux3 adc3 0.04044f
C1290 adc_sample adc_dac4 0.01053f
C1291 adc_refs1 bg_en 1.67411f
C1292 por_n bod_o 35.4626f
C1293 xo_mode0 clk_xa 0.05771f
C1294 vbp avdd 5.97706f
C1295 xo_mode1 xo_en 0.17488f
C1296 bod_en rv328_glue_0/rv328_glue_p0_0/gf180mcu_fd_sc_mcu9t5v0__inv_1_8/ZN 0.00172f
C1297 aco clk_lf 0.06891f
C1298 vref aref 60.3666f
C1299 rc_trim1 xo_mode0 0
C1300 ac_out xo_en 0.01897f
C1301 rv328_glue_0/rv328_glue_p0_0/gf180mcu_fd_sc_mcu9t5v0__nor2_1_2/ZN adc_en 0.82096f
C1302 adc_dac0 bod_level0 0.04608f
C1303 amx adc_dac6 0.04709f
C1304 en_avcc xo_mode0 0
C1305 adc_dac2 adc_mux2 0.04044f
C1306 vbp adc_dac0 0.04613f
C1307 adc_sample adc_dac6 0.01564f
C1308 adc_mux3 adc_mux0 0.04122f
C1309 adc_refs0 rc_trim0 0.04804f
C1310 bod_level2 avdd 1.55633f
C1311 rc_trim6 ac_en 0.08344f
C1312 aref rv328_glue_0/rv328_glue_p0_0/gf180mcu_fd_sc_mcu9t5v0__inv_1_5/ZN 0.00127f
C1313 rc_trim3 rc_trim2 37.801f
C1314 amx xo_mode1 0.05907f
C1315 ac_out amx 0.05907f
C1316 clk_rc adc_dac7 0
C1317 adc_dac5 adc_dac7 0.0426f
C1318 por_n avdd 7.03277f
C1319 bod_en rc_trim0 0.0958f
C1320 adc_dac0 bod_level2 0.05368f
C1321 adc_sample xo_mode1 0
C1322 adc_dac3 bod_level0 0.04044f
C1323 ac_out adc_sample 0.08973f
C1324 rv328_glue_0/rv328_glue_p0_0/gf180mcu_fd_sc_mcu9t5v0__nand2_1_4/ZN adc_refs0 0.02514f
C1325 rv328_glue_0/rv328_glue_p0_0/gf180mcu_fd_sc_mcu9t5v0__inv_1_4/I en_buf 1.16128f
C1326 avdd rv328_glue_0/rv328_glue_p0_0/gf180mcu_fd_sc_mcu9t5v0__nand2_1_5/a_245_69# 0
C1327 adc_dac3 vbp 0.04613f
C1328 bod_o adc_mux1 0.04548f
C1329 bod_o adc_en 0.04548f
C1330 en_buf bg_en 0.04108f
C1331 rc_trim2 adc_refs0 0.04044f
C1332 adc_mux3 ac_en 0.04063f
C1333 rv328_glue_0/rv328_glue_p0_0/gf180mcu_fd_sc_mcu9t5v0__nand2_1_0/a_245_69# ac_en 0
C1334 adc_dac3 bod_level2 0.04804f
C1335 rc_trim3 cmpa 0.0452f
C1336 rc_trim7 rc_trim6 37.3832f
C1337 adc_refs0 rv328_glue_0/rv328_glue_p0_0/gf180mcu_fd_sc_mcu9t5v0__nor2_1_1/ZN 0.0176f
C1338 rc_trim2 bod_en 0.0882f
C1339 xo_en rv328_glue_0/rv328_glue_p0_0/gf180mcu_fd_sc_mcu9t5v0__nand2_1_7/ZN 0.1373f
C1340 rc_trim5 adc_mux0 0.04044f
C1341 avdd adc_mux1 1.34541f
C1342 adc_cmp rv328_glue_0/rv328_glue_p0_0/gf180mcu_fd_sc_mcu9t5v0__inv_1_3/I 0.02082f
C1343 bod_en rv328_glue_0/rv328_glue_p0_0/gf180mcu_fd_sc_mcu9t5v0__nor2_1_1/ZN 0.14849f
C1344 lv1 bod_level1 0.06049f
C1345 adc_en avdd 18.07006f
C1346 rc_trim3 adc_dac8 0.04044f
C1347 adc_dac0 adc_mux1 0.04608f
C1348 rv328_glue_0/rv328_glue_p0_0/gf180mcu_fd_sc_mcu9t5v0__nor2_1_2/ZN xo_mode0 0
C1349 aref adc_dac2 0.2369f
C1350 adc_dac0 adc_en 0.09694f
C1351 adc_refs0 cmpa 0.11709f
C1352 aco rv328_glue_0/rv328_glue_p0_0/gf180mcu_fd_sc_mcu9t5v0__inv_1_2/I 0.01498f
C1353 adc_mux3 rc_trim7 0.04044f
C1354 adc_sample rv328_glue_0/rv328_glue_p0_0/gf180mcu_fd_sc_mcu9t5v0__nand2_1_7/ZN 0.02046f
C1355 rv328_glue_0/rv328_glue_p0_0/gf180mcu_fd_sc_mcu9t5v0__inv_1_7/I rv328_glue_0/rv328_glue_p0_0/gf180mcu_fd_sc_mcu9t5v0__nor2_1_0/a_234_573# 0.02957f
C1356 adc_dac9 rc_trim0 0.0452f
C1357 ok bg_en 11.8445f
C1358 bod_level0 adc_refs1 0
C1359 rv328_acsw_0/rv328_acsw_p0_0/gf180mcu_fd_sc_mcu9t5v0__inv_1_0/ZN avdd 2.87609f
C1360 bod_en cmpa 0.13539f
C1361 smp rv328_glue_0/rv328_glue_p0_0/gf180mcu_fd_sc_mcu9t5v0__inv_1_0/I 0
C1362 rc_trim5 ac_en 0.08344f
C1363 rc_trim4 bod_level0 0.04044f
C1364 vbp adc_refs1 0.14546f
C1365 rc_trim3 adc_dac1 0.04044f
C1366 vbp rc_trim4 0.13938f
C1367 adc_dac3 adc_mux1 0.04044f
C1368 smp mux_en 7.2267f
C1369 rv328_glue_0/rv328_glue_p0_0/gf180mcu_fd_sc_mcu9t5v0__inv_1_8/ZN xo_en 0.00962f
C1370 clk_xa adc_mux0 0.04044f
C1371 adc_dac3 adc_en 0.0913f
C1372 adc_refs0 adc_dac8 0.04044f
C1373 adc4 avdd 0.4361f
C1374 rc_trim1 adc_mux0 0.04044f
C1375 bod_level2 adc_refs1 0.04154f
C1376 bod_en adc_dac8 0.04044f
C1377 acp vtemp 2.45633f
C1378 bod_level2 rc_trim4 0.04695f
C1379 rc_trim2 adc_dac9 0.0452f
C1380 adc_dac1 adc_refs0 0.04044f
C1381 rc_trim0 xo_en 0.01061f
C1382 smp adc_dac4 0.04614f
C1383 aco adc5 0.05164f
C1384 vref rv328_glue_0/rv328_glue_p0_0/gf180mcu_fd_sc_mcu9t5v0__inv_1_7/I 0
C1385 ac_mux_en ac_bg 9.75304f
C1386 rc_trim7 rc_trim5 0.04216f
C1387 bod_en adc_dac1 0.04044f
C1388 rv328_glue_0/rv328_glue_p0_0/gf180mcu_fd_sc_mcu9t5v0__inv_1_1/I cmpa 2.1177f
C1389 rc_trim1 ac_en 0.08344f
C1390 vbp en_buf 2.693f
C1391 clk_xa ac_en 0.10049f
C1392 smp adc_dac6 0.0462f
C1393 ain1 mux_en 0.00716f
C1394 rv328_glue_0/rv328_glue_p0_0/gf180mcu_fd_sc_mcu9t5v0__inv_1_7/I rv328_glue_0/rv328_glue_p0_0/gf180mcu_fd_sc_mcu9t5v0__inv_1_5/ZN 0
C1395 avdd xo_mode0 1.32105f
C1396 amx rc_trim0 0.05772f
C1397 rc_trim3 rc_en 0.04088f
C1398 rv328_glue_0/rv328_glue_p0_0/gf180mcu_fd_sc_mcu9t5v0__inv_1_7/I aref 0.00202f
C1399 en_avcc ac_en 0.0923f
C1400 adc_dac9 cmpa 15.2019f
C1401 adc_dac0 xo_mode0 0.04608f
C1402 bod_level2 en_buf 0.10526f
C1403 smp xo_mode1 0.07216f
C1404 rc_trim2 xo_en 0.01423f
C1405 smp ac_out 0.11845f
C1406 adc_refs1 adc_mux1 0.04044f
C1407 rv328_glue_0/rv328_glue_p0_0/gf180mcu_fd_sc_mcu9t5v0__inv_1_4/I rv328_glue_0/rv328_glue_p0_0/gf180mcu_fd_sc_mcu9t5v0__inv_1_6/ZN 0.23853f
C1408 adc_en adc_refs1 0.21996f
C1409 rc_trim4 adc_mux1 0.04044f
C1410 xo_en rv328_glue_0/rv328_glue_p0_0/gf180mcu_fd_sc_mcu9t5v0__nor2_1_1/ZN 0.00113f
C1411 rv328_glue_0/rv328_glue_p0_0/gf180mcu_fd_sc_mcu9t5v0__nand2_1_4/ZN adc_sample 0.03315f
C1412 rv328_glue_0/rv328_glue_p0_0/gf180mcu_fd_sc_mcu9t5v0__nand3_1_0/a_271_69# rv328_glue_0/rv328_glue_p0_0/gf180mcu_fd_sc_mcu9t5v0__inv_1_5/ZN 0.00297f
C1413 rc_trim4 adc_en 0.08088f
C1414 adc_refs0 rc_en 0.04804f
C1415 rc_trim1 rc_trim7 0.04063f
C1416 ac_mux_en acm 1.59062f
C1417 adc_dac3 xo_mode0 0.04044f
C1418 adc_dac9 adc_dac8 42.208f
C1419 rc_trim2 amx 0.05772f
C1420 lv1 clk_rc 0.10279f
C1421 bod_level1 mux_en 0.05889f
C1422 bod_en rc_en 0.09587f
C1423 ok bod_level0 0.09638f
C1424 aco adc_refs0 0.02392f
C1425 aco adc0 0.06028f
C1426 ok vbp 1.15853f
C1427 cmpa xo_en 0.06547f
C1428 adc_sample rv328_glue_0/rv328_glue_p0_0/gf180mcu_fd_sc_mcu9t5v0__nor2_1_1/ZN 0.01759f
C1429 aco bod_en 0.06062f
C1430 adc_dac1 adc_dac9 0.04533f
C1431 ok bod_level2 0.05632f
C1432 adc_dac4 bod_level1 0.04044f
C1433 amx cmpa 0.11617f
C1434 adc_cmp ac_mux_en 0.09986f
C1435 adc_en en_buf 0.07037f
C1436 adc_cmp rv328_glue_0/rv328_glue_p0_0/gf180mcu_fd_sc_mcu9t5v0__inv_1_8/I 0.01437f
C1437 smp rv328_glue_0/rv328_glue_p0_0/gf180mcu_fd_sc_mcu9t5v0__nand2_1_7/ZN 0.02074f
C1438 rv328_glue_0/rv328_glue_p0_0/gf180mcu_fd_sc_mcu9t5v0__nor2_1_2/ZN ac_en 0.27487f
C1439 rv328_glue_0/rv328_glue_p0_0/gf180mcu_fd_sc_mcu9t5v0__nand2_1_3/a_245_69# rv328_glue_0/rv328_glue_p0_0/gf180mcu_fd_sc_mcu9t5v0__inv_1_6/ZN 0
C1440 ok por_n 0.05164f
C1441 adc_dac8 xo_en 0.04044f
C1442 bod_o adc_mux0 0.04548f
C1443 vbp clk_lf 0.05509f
C1444 adc_sample cmpa 7.02024f
C1445 rv328_glue_0/rv328_glue_p0_0/gf180mcu_fd_sc_mcu9t5v0__inv_1_3/I en_avcc 1.42508f
C1446 ac_bg adc_mux2 0.04319f
C1447 aco ain0 0.06028f
C1448 bod_level1 adc_dac6 0.04044f
C1449 adc3 avdd 0.4361f
C1450 ac_mux_en rc_trim6 0.08088f
C1451 amx adc_dac8 0.04709f
C1452 bod_level1 xo_mode1 0.08866f
C1453 adc_dac1 xo_en 0.04044f
C1454 adc_refs1 xo_mode0 0.08572f
C1455 ac_out bod_level1 0
C1456 adc_dac4 adc_dac7 0.04144f
C1457 aco rv328_glue_0/rv328_glue_p0_0/gf180mcu_fd_sc_mcu9t5v0__inv_1_1/I 0.0208f
C1458 clk_lf por_n 0.05384f
C1459 avdd adc_mux0 1.34189f
C1460 adc_sample adc_dac8 0.03039f
C1461 aco adc2 0.05164f
C1462 rc_trim4 xo_mode0 0
C1463 adc_dac9 rc_en 0.0528f
C1464 bod_o ac_en 0.04548f
C1465 adc_dac0 adc_mux0 0.04608f
C1466 adc_dac7 adc_dac6 41.8244f
C1467 rv328_glue_0/rv328_glue_p0_0/gf180mcu_fd_sc_mcu9t5v0__nand2_1_1/a_245_69# cmpa 0
C1468 ok adc_en 0.04044f
C1469 amx adc_dac1 0.04709f
C1470 smp rv328_glue_0/rv328_glue_p0_0/gf180mcu_fd_sc_mcu9t5v0__inv_1_8/ZN 0.0477f
C1471 adc_mux3 ac_mux_en 0.04072f
C1472 rv328_glue_0/rv328_glue_p0_0/gf180mcu_fd_sc_mcu9t5v0__nand3_1_0/a_455_69# avdd 0
C1473 acm adc_mux2 0
C1474 vref ac_bg 2.02936f
C1475 adc_dac7 xo_mode1 0.04179f
C1476 ac_out adc_dac7 0.04683f
C1477 avdd ac_en 7.88783f
C1478 adc_dac3 adc_mux0 0.04044f
C1479 smp rc_trim0 0.04844f
C1480 clk_lf adc_mux1 0.05771f
C1481 en_buf xo_mode0 0
C1482 clk_lf adc_en 0.05771f
C1483 rv328_glue_0/rv328_glue_p0_0/gf180mcu_fd_sc_mcu9t5v0__inv_1_4/I adc_refs0 0.67048f
C1484 adc_dac0 ac_en 0.04608f
C1485 bod_level2 rv328_glue_0/rv328_glue_p0_0/gf180mcu_fd_sc_mcu9t5v0__inv_1_6/ZN 0
C1486 bod_level1 rv328_glue_0/rv328_glue_p0_0/gf180mcu_fd_sc_mcu9t5v0__nand2_1_7/ZN 0.02051f
C1487 rv328_glue_0/rv328_glue_p0_0/gf180mcu_fd_sc_mcu9t5v0__nand3_1_1/a_271_69# adc_refs0 0.00292f
C1488 clk_rc mux_en 0.09711f
C1489 aco xo_en 0.01896f
C1490 smp rv328_glue_0/rv328_glue_p0_0/gf180mcu_fd_sc_mcu9t5v0__nand2_1_4/ZN 0.04571f
C1491 xo_mode1 rv328_glue_0/rv328_glue_p0_0/gf180mcu_fd_sc_mcu9t5v0__nand2_1_7/a_245_69# 0
C1492 acp mux_en 3.67759f
C1493 adc_refs0 bg_en 0.10532f
C1494 mux_en vtemp 0.06085f
C1495 adc_cmp adc_mux2 0.04908f
C1496 rv328_acsw_0/rv328_acsw_p0_0/gf180mcu_fd_sc_mcu9t5v0__inv_1_1/ZN rv328_acsw_0/rv328_acsw_p0_0/gf180mcu_fd_sc_mcu9t5v0__inv_1_0/ZN 0.34499f
C1497 amx rc_en 0.06276f
C1498 ac_mux_en rc_trim5 0.08088f
C1499 bod_en bg_en 6.03395f
C1500 rc_trim7 avdd 4.78803f
C1501 adc_dac3 ac_en 0.04044f
C1502 smp rc_trim2 0.04844f
C1503 aco amx 0.05772f
C1504 vref acm 0.32402f
C1505 rv328_glue_0/rv328_glue_p0_0/gf180mcu_fd_sc_mcu9t5v0__nand3_1_1/a_455_69# avdd 0
C1506 adc_dac5 adc_dac4 41.4456f
C1507 smp rv328_glue_0/rv328_glue_p0_0/gf180mcu_fd_sc_mcu9t5v0__nor2_1_1/ZN 0.0294f
C1508 aco adc_sample 0.14279f
C1509 rc_trim6 adc_mux2 0.04044f
C1510 adc_dac0 rc_trim7 0.04608f
C1511 ok xo_mode0 0.09816f
C1512 aco adc6 0.05164f
C1513 adc_dac5 adc_dac6 41.635f
C1514 bod_level1 rv328_glue_0/rv328_glue_p0_0/gf180mcu_fd_sc_mcu9t5v0__inv_1_8/ZN 0.00653f
C1515 adc1 aco 0.05164f
C1516 vbp adc5 0.04646f
C1517 adc_refs1 adc_mux0 0.04044f
C1518 adc_en rv328_glue_0/rv328_glue_p0_0/gf180mcu_fd_sc_mcu9t5v0__inv_1_6/ZN 1.0377f
C1519 smp cmpa 70.72961f
C1520 ac_bg adc_dac2 0.04179f
C1521 rc_trim4 adc_mux0 0.04044f
C1522 adc_cmp vref 0.1697f
C1523 clk_rc xo_mode1 0.06027f
C1524 adc_dac5 xo_mode1 0.04179f
C1525 adc_dac3 rc_trim7 0.04044f
C1526 ac_out clk_rc 0.06055f
C1527 ac_out adc_dac5 0.04683f
C1528 rv328_glue_0/rv328_glue_p0_0/gf180mcu_fd_sc_mcu9t5v0__inv_1_3/I avdd 0.89398f
C1529 rc_trim1 ac_mux_en 0.08088f
C1530 adc_mux3 adc_mux2 56.3491f
C1531 ac_mux_en clk_xa 0.09793f
C1532 rv328_glue_0/rv328_glue_p0_0/gf180mcu_fd_sc_mcu9t5v0__nand2_1_7/a_245_69# rv328_glue_0/rv328_glue_p0_0/gf180mcu_fd_sc_mcu9t5v0__nand2_1_7/ZN 0.0162f
C1533 ac_mux_en en_avcc 0.08248f
C1534 bod_level1 rc_trim0 0.04818f
C1535 en_avcc rv328_glue_0/rv328_glue_p0_0/gf180mcu_fd_sc_mcu9t5v0__inv_1_8/I 0.01437f
C1536 rv328_glue_0/rv328_glue_p0_0/gf180mcu_fd_sc_mcu9t5v0__inv_1_2/I adc_en 1.31815f
C1537 rc_trim3 bod_level0 0.04044f
C1538 adc_cmp rv328_glue_0/rv328_glue_p0_0/gf180mcu_fd_sc_mcu9t5v0__inv_1_5/ZN 0.01911f
C1539 vbp rc_trim3 0.13938f
C1540 vref rc_trim6 0.15243f
C1541 smp adc_dac8 0.04636f
C1542 adc_cmp aref 0.13749f
C1543 lv1 mux_en 57.35518f
C1544 rv328_glue_0/rv328_glue_p0_0/gf180mcu_fd_sc_mcu9t5v0__nand2_1_4/ZN bod_level1 0
C1545 adc_refs1 ac_en 0.32038f
C1546 rc_trim4 ac_en 0.08344f
C1547 rc_trim3 bod_level2 0.04695f
C1548 amx adc7 8.93854f
C1549 adc_refs0 bod_level0 0
C1550 smp adc_dac1 0.04608f
C1551 aref rc_trim6 0.13622f
C1552 rc_trim2 bod_level1 0.04044f
C1553 adc_dac7 rc_trim0 0.04044f
C1554 vbp adc_refs0 0.16164f
C1555 adc_mux3 vref 0.05168f
C1556 adc6 adc7 12.2234f
C1557 bod_en bod_level0 59.402f
C1558 vbp adc0 0.05323f
C1559 rv328_glue_0/rv328_glue_p0_0/gf180mcu_fd_sc_mcu9t5v0__nand3_1_0/a_455_69# en_buf 0
C1560 bod_level1 rv328_glue_0/rv328_glue_p0_0/gf180mcu_fd_sc_mcu9t5v0__nor2_1_1/ZN 0.04606f
C1561 adc5 adc_mux1 0.04044f
C1562 rc_trim5 adc_mux2 0.04044f
C1563 vbp bod_en 0.15051f
C1564 adc5 adc_en 0.04044f
C1565 rc_trim7 adc_refs1 0.0452f
C1566 bod_level2 adc_refs0 0.04118f
C1567 xo_en bg_en 0.06042f
C1568 rc_trim7 rc_trim4 0.04122f
C1569 rv328_glue_0/rv328_glue_p0_0/gf180mcu_fd_sc_mcu9t5v0__nand3_1_1/a_455_69# adc_refs1 0
C1570 en_buf ac_en 0.0708f
C1571 bod_en bod_level2 0.08808f
C1572 bod_level1 cmpa 0.1053f
C1573 adc_cmp adc_dac2 0.04548f
C1574 adc_sample rv328_glue_0/rv328_glue_p0_0/gf180mcu_fd_sc_mcu9t5v0__inv_1_4/I 0.03617f
C1575 lv1 xo_mode1 0.14395f
C1576 ac_mux_en rv328_glue_0/rv328_glue_p0_0/gf180mcu_fd_sc_mcu9t5v0__nor2_1_2/ZN 0.0348f
C1577 rc_trim2 adc_dac7 0.04044f
C1578 lv1 ac_out 0.06084f
C1579 rv328_glue_0/rv328_glue_p0_0/gf180mcu_fd_sc_mcu9t5v0__nor2_1_2/ZN rv328_glue_0/rv328_glue_p0_0/gf180mcu_fd_sc_mcu9t5v0__inv_1_8/I 0.08549f
C1580 vbp ain0 0.05406f
C1581 bod_en por_n 0.05164f
C1582 rc_trim3 adc_mux1 0.04044f
C1583 rc_trim3 adc_en 0.08088f
C1584 adc_sample bg_en 4.61174f
C1585 smp rc_en 0.05605f
C1586 adc_mux2 clk_xa 0.04044f
C1587 adc5 adc4 12.1615f
C1588 rc_trim1 adc_mux2 0.04044f
C1589 rv328_glue_0/rv328_glue_p0_0/gf180mcu_fd_sc_mcu9t5v0__inv_1_3/I adc_refs1 0
C1590 smp aco 0.11029f
C1591 bod_level1 adc_dac8 0.04044f
C1592 adc_dac2 rc_trim6 0.04044f
C1593 vref rc_trim5 0.15243f
C1594 rv328_glue_0/rv328_glue_p0_0/gf180mcu_fd_sc_mcu9t5v0__nand2_1_4/a_245_69# avdd 0
C1595 vbp adc2 0.04646f
C1596 clk_lf adc_mux0 0.05771f
C1597 adc_dac7 cmpa 0.119f
C1598 adc_refs0 adc_mux1 0.06757f
C1599 adc_dac9 bod_level0 0.0452f
C1600 ok ac_en 0.043f
C1601 ac_mux_en bod_o 0.04548f
C1602 adc_refs0 adc_en 51.30268f
C1603 vbp adc_dac9 0.0575f
C1604 adc0 adc_mux1 0.04853f
C1605 adc_dac1 bod_level1 0.04044f
C1606 bod_en adc_mux1 0.04044f
C1607 rc_trim5 aref 0.13622f
C1608 adc0 adc_en 0.04853f
C1609 clk_rc rc_trim0 0.01258f
C1610 adc_dac5 rc_trim0 0.04044f
C1611 adc_mux3 adc_dac2 0.04044f
C1612 bod_en adc_en 0.18708f
C1613 bod_level2 adc_dac9 0.0528f
C1614 lv1 rv328_glue_0/rv328_glue_p0_0/gf180mcu_fd_sc_mcu9t5v0__nand2_1_7/ZN 0.02057f
C1615 adc_dac7 adc_dac8 42.0138f
C1616 rv328_glue_0/rv328_glue_p0_0/gf180mcu_fd_sc_mcu9t5v0__nand2_1_2/a_245_69# avdd 0
C1617 ain1 aco 0.06028f
C1618 rv328_glue_0/rv328_glue_p0_0/gf180mcu_fd_sc_mcu9t5v0__inv_1_3/I en_buf 0.00435f
C1619 vref clk_xa 0.16948f
C1620 rc_trim1 vref 0.15243f
C1621 ac_mux_en avdd 11.97357f
C1622 adc_cmp rv328_glue_0/rv328_glue_p0_0/gf180mcu_fd_sc_mcu9t5v0__inv_1_7/I 0.01991f
C1623 avdd rv328_glue_0/rv328_glue_p0_0/gf180mcu_fd_sc_mcu9t5v0__inv_1_8/I 0.48355f
C1624 clk_lf ac_en 0.05771f
C1625 ain0 adc_mux1 0
C1626 vref en_avcc 0.04736f
C1627 ain0 adc_en 0.05633f
C1628 bod_level0 xo_en 0.04044f
C1629 ok rc_trim7 0.08952f
C1630 adc_dac0 ac_mux_en 0.04608f
C1631 rc_trim2 adc_dac5 0.04044f
C1632 adc_dac1 adc_dac7 0.04069f
C1633 vbp xo_en 0.20032f
C1634 rc_trim3 xo_mode0 0
C1635 aref clk_xa 0.20441f
C1636 rc_trim1 aref 0.13622f
C1637 bod_level1 rc_en 0.04823f
C1638 en_avcc rv328_glue_0/rv328_glue_p0_0/gf180mcu_fd_sc_mcu9t5v0__inv_1_5/ZN 0.02685f
C1639 amx bod_level0 0.05772f
C1640 aref en_avcc 0.52822f
C1641 bod_level2 xo_en 0.12243f
C1642 rv328_glue_0/rv328_glue_p0_0/gf180mcu_fd_sc_mcu9t5v0__inv_1_1/I adc_en 0.71257f
C1643 adc2 adc_mux1 0.04044f
C1644 rv328_acsw_0/rv328_acsw_p0_0/gf180mcu_fd_sc_mcu9t5v0__inv_1_0/ZN ain0 0.03618f
C1645 lv1 rv328_glue_0/rv328_glue_p0_0/gf180mcu_fd_sc_mcu9t5v0__inv_1_8/ZN 0
C1646 rc_trim5 adc_dac2 0.04044f
C1647 adc2 adc_en 0.04044f
C1648 adc_dac3 ac_mux_en 0.04044f
C1649 adc_sample bod_level0 0.05584f
C1650 vbp amx 0.14341f
C1651 aco bod_level1 0
C1652 ac_out rv328_glue_0/rv328_glue_p0_0/gf180mcu_fd_sc_mcu9t5v0__inv_1_0/I 1.57808f
C1653 adc_dac9 adc_mux1 0.0452f
C1654 vbp adc_sample 0.1695f
C1655 adc_dac9 adc_en 0.10742f
C1656 clk_rc cmpa 0.04327f
C1657 adc_dac5 cmpa 0.12371f
C1658 adc_refs0 xo_mode0 0.08095f
C1659 mux_en xo_mode1 0.14249f
C1660 ac_out mux_en 0.04436f
C1661 vbp adc6 0.04646f
C1662 amx bod_level2 0.06276f
C1663 adc_dac4 adc_dac6 0.0426f
C1664 adc_sample bod_level2 0.04891f
C1665 rv328_glue_0/rv328_glue_p0_0/gf180mcu_fd_sc_mcu9t5v0__nor2_1_1/a_234_573# avdd 0.02876f
C1666 adc1 vbp 0.04646f
C1667 lv1 rc_trim0 0.09543f
C1668 bod_en xo_mode0 0.12879f
C1669 adc_dac7 rc_en 0.04804f
C1670 amx por_n 0.05772f
C1671 smp rv328_glue_0/rv328_glue_p0_0/gf180mcu_fd_sc_mcu9t5v0__inv_1_4/I 0.04035f
C1672 bod_o adc_mux2 0.04548f
C1673 adc_dac4 xo_mode1 0.04179f
C1674 adc_sample por_n 0
C1675 clk_rc adc_dac8 0
C1676 adc_dac5 adc_dac8 0.04144f
C1677 aco adc_dac7 0.01061f
C1678 ac_out adc_dac4 0.04683f
C1679 smp bg_en 0.04062f
C1680 lv1 rv328_glue_0/rv328_glue_p0_0/gf180mcu_fd_sc_mcu9t5v0__nand2_1_4/ZN 0
C1681 rc_trim1 adc_dac2 0.04044f
C1682 rv328_glue_0/rv328_glue_p0_0/gf180mcu_fd_sc_mcu9t5v0__inv_1_2/I ac_en 0.01915f
C1683 xo_en adc_mux1 0.04044f
C1684 adc_en xo_en 0.42308f
C1685 adc_dac6 xo_mode1 0.04179f
C1686 ac_out adc_dac6 0.04683f
C1687 adc5 adc_mux0 0.04044f
C1688 avdd adc_mux2 1.35095f
C1689 adc_dac5 adc_dac1 0.041f
C1690 lv1 rc_trim2 0.08758f
C1691 aref rv328_glue_0/rv328_glue_p0_0/gf180mcu_fd_sc_mcu9t5v0__nor2_1_2/ZN 0.00334f
C1692 ac_mux_en adc_refs1 0.08233f
C1693 adc_refs1 rv328_glue_0/rv328_glue_p0_0/gf180mcu_fd_sc_mcu9t5v0__inv_1_8/I 0.01437f
C1694 lv1 rv328_glue_0/rv328_glue_p0_0/gf180mcu_fd_sc_mcu9t5v0__nor2_1_1/ZN 0.02044f
C1695 rv328_glue_0/rv328_glue_p0_0/gf180mcu_fd_sc_mcu9t5v0__nor2_1_0/a_234_573# avdd 0.02898f
C1696 amx adc_mux1 0.05667f
C1697 ac_out xo_mode1 0
C1698 ac_mux_en rc_trim4 0.08088f
C1699 adc_dac0 adc_mux2 0.04608f
C1700 amx adc_en 0.1129f
C1701 mux_en rv328_glue_0/rv328_glue_p0_0/gf180mcu_fd_sc_mcu9t5v0__nand2_1_7/ZN 0.02063f
C1702 adc_sample adc_mux1 0.04908f
C1703 ac_bg acm 0.11287f
C1704 adc_sample adc_en 0.81491f
C1705 vref bod_o 0.05758f
C1706 adc6 adc_mux1 0.04044f
C1707 adc6 adc_en 0.04044f
C1708 adc_dac9 xo_mode0 0.0452f
C1709 rc_trim3 adc_mux0 0.04044f
C1710 adc1 adc_mux1 0.04044f
C1711 lv1 cmpa 0.0944f
C1712 adc1 adc_en 0.04044f
C1713 adc5 ac_en 0.04044f
C1714 amx rv328_acsw_0/rv328_acsw_p0_0/gf180mcu_fd_sc_mcu9t5v0__inv_1_0/ZN 0.75619f
C1715 adc_dac3 adc_mux2 0.04044f
C1716 rv328_glue_0/rv328_glue_p0_0/gf180mcu_fd_sc_mcu9t5v0__inv_1_3/I rv328_glue_0/rv328_glue_p0_0/gf180mcu_fd_sc_mcu9t5v0__inv_1_6/ZN 0
C1717 amx adc4 0.05772f
C1718 clk_rc rc_en 17.8875f
C1719 adc_dac5 rc_en 0.04804f
C1720 vref avdd 9.48805f
C1721 ac_mux_en en_buf 0.04051f
C1722 en_buf rv328_glue_0/rv328_glue_p0_0/gf180mcu_fd_sc_mcu9t5v0__inv_1_8/I 0.01437f
C1723 adc_cmp ac_bg 0.05164f
C1724 rv328_glue_0/rv328_glue_p0_0/gf180mcu_fd_sc_mcu9t5v0__inv_1_8/ZN mux_en 0
C1725 adc_refs0 adc_mux0 0.06352f
C1726 aco clk_rc 0.11489f
C1727 aco adc_dac5 0.01416f
C1728 bod_level1 bg_en 0.19274f
C1729 rv328_glue_0/rv328_glue_p0_0/gf180mcu_fd_sc_mcu9t5v0__inv_1_7/I en_avcc 0.0144f
C1730 rv328_glue_0/rv328_glue_p0_0/gf180mcu_fd_sc_mcu9t5v0__nand2_1_1/a_245_69# adc_en 0
C1731 rv328_glue_0/rv328_glue_p0_0/gf180mcu_fd_sc_mcu9t5v0__inv_1_2/I rv328_glue_0/rv328_glue_p0_0/gf180mcu_fd_sc_mcu9t5v0__inv_1_3/I 0.00728f
C1732 rc_trim3 ac_en 0.08344f
C1733 adc0 adc_mux0 0.04853f
C1734 acp aco 1.19114f
C1735 avdd rv328_glue_0/rv328_glue_p0_0/gf180mcu_fd_sc_mcu9t5v0__inv_1_5/ZN 0.4514f
C1736 xo_mode0 xo_en 91.78856f
C1737 xo_mode1 rv328_glue_0/rv328_glue_p0_0/gf180mcu_fd_sc_mcu9t5v0__nand2_1_7/ZN 1.84678f
C1738 bod_en adc_mux0 0.04044f
C1739 aref avdd 3.13393f
C1740 ac_out rv328_glue_0/rv328_glue_p0_0/gf180mcu_fd_sc_mcu9t5v0__nand2_1_7/ZN 0.02046f
C1741 smp bod_level0 0.09528f
C1742 ac_bg rc_trim6 0.043f
C1743 adc_dac0 aref 0.25944f
C1744 mux_en rc_trim0 0.09183f
C1745 smp vbp 0.22206f
C1746 amx xo_mode0 0.05772f
C1747 adc_refs0 ac_en 0.15802f
C1748 ain0 adc_mux0 0
C1749 adc_sample xo_mode0 0
C1750 smp bod_level2 0.1301f
C1751 adc0 ac_en 0.04853f
C1752 ok ac_mux_en 0.04044f
C1753 adc_mux2 adc_refs1 0.04044f
C1754 rv328_glue_0/rv328_glue_p0_0/gf180mcu_fd_sc_mcu9t5v0__nand2_1_4/ZN mux_en 1.17096f
C1755 rc_trim3 rc_trim7 0.04088f
C1756 rc_trim4 adc_mux2 0.04044f
C1757 bod_en ac_en 0.36891f
C1758 adc2 adc3 12.0996f
C1759 adc_mux3 ac_bg 0.04309f
C1760 smp por_n 15.6646f
C1761 adc_dac3 aref 0.2369f
C1762 adc_dac4 rc_trim0 0.04044f
C1763 rv328_glue_0/rv328_glue_p0_0/gf180mcu_fd_sc_mcu9t5v0__inv_1_8/ZN xo_mode1 0.01342f
C1764 rc_trim2 mux_en 0.08372f
C1765 ain1 vbp 0.05323f
C1766 adc2 adc_mux0 0.04044f
C1767 adc_dac6 rc_trim0 0.04044f
C1768 ac_mux_en rv328_acsw_0/rv328_acsw_p0_0/gf180mcu_fd_sc_mcu9t5v0__inv_1_1/ZN 2.15876f
C1769 mux_en rv328_glue_0/rv328_glue_p0_0/gf180mcu_fd_sc_mcu9t5v0__nor2_1_1/ZN 0.02045f
C1770 rv328_glue_0/rv328_glue_p0_0/gf180mcu_fd_sc_mcu9t5v0__inv_1_8/I rv328_glue_0/rv328_glue_p0_0/gf180mcu_fd_sc_mcu9t5v0__nand2_1_6/a_245_69# 0.0162f
C1771 adc_dac2 avdd 1.00164f
C1772 clk_lf ac_mux_en 0.05771f
C1773 rc_trim7 adc_refs0 0.04044f
C1774 lv1 rc_en 0.09577f
C1775 ain0 ac_en 0.04804f
C1776 rv328_glue_0/rv328_glue_p0_0/gf180mcu_fd_sc_mcu9t5v0__inv_1_7/I rv328_glue_0/rv328_glue_p0_0/gf180mcu_fd_sc_mcu9t5v0__nor2_1_2/ZN 0.24569f
C1777 adc_dac9 adc_mux0 0.0452f
C1778 rv328_glue_0/rv328_glue_p0_0/gf180mcu_fd_sc_mcu9t5v0__inv_1_0/I cmpa 0.17512f
C1779 rc_trim2 adc_dac4 0.04044f
C1780 adc_dac0 adc_dac2 0.0426f
C1781 bod_en rc_trim7 0.0882f
C1782 lv1 aco 0.05949f
C1783 smp adc_mux1 0.09024f
C1784 vref adc_refs1 0.15244f
C1785 cmpa mux_en 0.05965f
C1786 rv328_glue_0/rv328_glue_p0_0/gf180mcu_fd_sc_mcu9t5v0__inv_1_1/I ac_en 0.04821f
C1787 smp adc_en 0.42436f
C1788 rc_trim2 adc_dac6 0.04044f
C1789 vref rc_trim4 0.15243f
C1790 adc2 ac_en 0.04044f
C1791 ac_bg rc_trim5 0.043f
C1792 bod_level1 bod_level0 16.677f
C1793 ac_out rv328_glue_0/rv328_glue_p0_0/gf180mcu_fd_sc_mcu9t5v0__nand2_1_4/ZN 0.02674f
C1794 vbp bod_level1 0.15049f
C1795 adc_dac3 adc_dac2 41.0668f
C1796 rv328_glue_0/rv328_glue_p0_0/gf180mcu_fd_sc_mcu9t5v0__inv_1_3/I adc_refs0 0.05081f
C1797 adc_refs1 rv328_glue_0/rv328_glue_p0_0/gf180mcu_fd_sc_mcu9t5v0__inv_1_5/ZN 1.09934f
C1798 adc_dac9 ac_en 0.0452f
C1799 aref adc_refs1 0.14002f
C1800 rv328_glue_0/rv328_glue_p0_0/gf180mcu_fd_sc_mcu9t5v0__inv_1_8/ZN rv328_glue_0/rv328_glue_p0_0/gf180mcu_fd_sc_mcu9t5v0__nand2_1_7/ZN 0.02811f
C1801 rc_trim2 xo_mode1 0
C1802 adc_dac4 cmpa 0.1274f
C1803 xo_en adc_mux0 0.04044f
C1804 aref rc_trim4 0.13622f
C1805 amx adc3 0.05772f
C1806 bod_level2 bod_level1 73.94704f
C1807 ac_out rv328_glue_0/rv328_glue_p0_0/gf180mcu_fd_sc_mcu9t5v0__nor2_1_1/ZN 0.01762f
C1808 xo_mode1 rv328_glue_0/rv328_glue_p0_0/gf180mcu_fd_sc_mcu9t5v0__nor2_1_1/ZN 0
C1809 cmpa adc_dac6 0.12103f
C1810 adc_cmp adc_mux3 0.04908f
C1811 vref en_buf 0.04736f
C1812 amx adc_mux0 0.05667f
C1813 ain1 adc_en 0.05682f
C1814 adc_cmp rv328_glue_0/rv328_glue_p0_0/gf180mcu_fd_sc_mcu9t5v0__nand2_1_0/a_245_69# 0
C1815 adc_dac7 bod_level0 0.04044f
C1816 vbp adc_dac7 0.04613f
C1817 rv328_glue_0/rv328_glue_p0_0/gf180mcu_fd_sc_mcu9t5v0__inv_1_7/I avdd 0.5239f
C1818 rc_trim1 ac_bg 0.043f
C1819 adc_dac4 adc_dac8 0.041f
C1820 adc_sample adc_mux0 0.04908f
C1821 ac_bg clk_xa 0.043f
C1822 rv328_glue_0/rv328_glue_p0_0/gf180mcu_fd_sc_mcu9t5v0__inv_1_2/I rv328_glue_0/rv328_glue_p0_0/gf180mcu_fd_sc_mcu9t5v0__nand2_1_2/a_245_69# 0.0162f
C1823 rc_trim7 adc_dac9 0.0452f
C1824 cmpa xo_mode1 0.04679f
C1825 ac_out cmpa 0.12312f
C1826 adc6 adc_mux0 0.04044f
C1827 xo_en ac_en 0.16009f
C1828 rv328_glue_0/rv328_glue_p0_0/gf180mcu_fd_sc_mcu9t5v0__inv_1_5/ZN en_buf 0.44527f
C1829 bod_level2 adc_dac7 0.04804f
C1830 adc_mux3 rc_trim6 0.04044f
C1831 aref en_buf 0.25067f
C1832 adc_dac8 adc_dac6 0.0426f
C1833 adc1 adc_mux0 0.04044f
C1834 ain1 rv328_acsw_0/rv328_acsw_p0_0/gf180mcu_fd_sc_mcu9t5v0__inv_1_0/ZN 0.55311f
C1835 adc_dac4 adc_dac1 0.04144f
C1836 clk_lf adc_mux2 0.05771f
C1837 rv328_glue_0/rv328_glue_p0_0/gf180mcu_fd_sc_mcu9t5v0__inv_1_3/I rv328_glue_0/rv328_glue_p0_0/gf180mcu_fd_sc_mcu9t5v0__inv_1_1/I 0
C1838 adc_dac2 adc_refs1 0.04044f
C1839 smp xo_mode0 0.08209f
C1840 rv328_glue_0/rv328_glue_p0_0/gf180mcu_fd_sc_mcu9t5v0__nand3_1_0/a_271_69# avdd 0.00109f
C1841 amx ac_en 0.06316f
C1842 adc_dac8 xo_mode1 0.04179f
C1843 bod_level1 adc_mux1 0.04044f
C1844 ac_out adc_dac8 0.04683f
C1845 bod_level1 adc_en 0.08175f
C1846 rc_trim4 adc_dac2 0.04044f
C1847 adc_dac1 adc_dac6 0.0408f
C1848 adc_sample ac_en 0.14949f
C1849 rv328_glue_0/rv328_glue_p0_0/gf180mcu_fd_sc_mcu9t5v0__nand2_1_7/ZN rv328_glue_0/rv328_glue_p0_0/gf180mcu_fd_sc_mcu9t5v0__nor2_1_1/ZN 0
C1850 mux_en rc_en 8.1033f
C1851 adc6 ac_en 0.04044f
C1852 rc_trim7 xo_en 33.0876f
C1853 ok vref 0.10017f
C1854 aco rv328_glue_0/rv328_glue_p0_0/gf180mcu_fd_sc_mcu9t5v0__inv_1_0/I 1.09587f
C1855 adc1 ac_en 0.04044f
C1856 ac_out adc_dac1 0.04683f
C1857 adc_dac1 xo_mode1 0.04179f
C1858 adc5 ac_mux_en 0.04044f
C1859 aco mux_en 0.04308f
C1860 lv1 bg_en 0.06116f
C1861 cmpa rv328_glue_0/rv328_glue_p0_0/gf180mcu_fd_sc_mcu9t5v0__nand2_1_7/ZN 0.02049f
C1862 amx rc_trim7 0.05772f
C1863 rc_trim5 rc_trim6 37.4876f
C1864 ok aref 0.13622f
C1865 adc_dac7 adc_mux1 0.04044f
C1866 vref rv328_acsw_0/rv328_acsw_p0_0/gf180mcu_fd_sc_mcu9t5v0__inv_1_1/ZN 0.30508f
C1867 adc_dac7 adc_en 0.0913f
C1868 adc_dac4 rc_en 0.04804f
C1869 clk_rc bod_level0 0.04721f
C1870 adc_dac5 bod_level0 0.04044f
C1871 clk_lf vref 0.06117f
C1872 vbp clk_rc 0.15982f
C1873 vbp adc_dac5 0.04613f
C1874 aco adc_dac4 0.017f
C1875 adc_cmp clk_xa 0.05821f
C1876 rv328_glue_0/rv328_glue_p0_0/gf180mcu_fd_sc_mcu9t5v0__inv_1_8/ZN rv328_glue_0/rv328_glue_p0_0/gf180mcu_fd_sc_mcu9t5v0__nor2_1_1/ZN 1.06949f
C1877 adc_dac6 rc_en 0.04804f
C1878 rc_trim3 ac_mux_en 0.08088f
C1879 vbp acp 0.1944f
C1880 vbp vtemp 0.11382f
C1881 adc_cmp en_avcc 0.07411f
C1882 adc_mux3 rc_trim5 0.04044f
C1883 bod_level2 clk_rc 0.05558f
C1884 adc_dac5 bod_level2 0.04804f
C1885 aco adc_dac6 0.01213f
C1886 rv328_glue_0/rv328_glue_p0_0/gf180mcu_fd_sc_mcu9t5v0__inv_1_7/I adc_refs1 0.02018f
C1887 rc_trim2 rc_trim0 0.04216f
C1888 clk_rc por_n 0
C1889 rv328_glue_0/rv328_glue_p0_0/gf180mcu_fd_sc_mcu9t5v0__inv_1_8/ZN cmpa 0
C1890 rc_trim1 rc_trim6 0.04072f
C1891 bod_level1 xo_mode0 0.08106f
C1892 adc_sample rv328_glue_0/rv328_glue_p0_0/gf180mcu_fd_sc_mcu9t5v0__inv_1_3/I 0.02866f
C1893 adc_refs0 rv328_glue_0/rv328_glue_p0_0/gf180mcu_fd_sc_mcu9t5v0__inv_1_8/I 0.01437f
C1894 ac_out aco 72.33533f
C1895 ac_mux_en adc_refs0 0.09094f
C1896 ac_bg bod_o 0.04804f
C1897 adc0 vss 2.88865f
C1898 adc1 vss 1.94457f
C1899 adc2 vss 1.95029f
C1900 adc3 vss 1.95579f
C1901 adc4 vss 1.96109f
C1902 adc5 vss 1.96619f
C1903 adc6 vss 1.97804f
C1904 adc7 vss 3.46817f
C1905 xtal2 vss 5.86142f
C1906 xtal1 vss 1.79744f
C1907 adc_dac9 vss 12.54586f
C1908 adc_dac8 vss 6.03507f
C1909 adc_dac7 vss 6.0001f
C1910 adc_dac6 vss 5.97646f
C1911 adc_dac5 vss 5.94089f
C1912 adc_dac4 vss 5.91361f
C1913 adc_dac3 vss 5.89743f
C1914 adc_dac2 vss 5.86607f
C1915 adc_dac1 vss 5.83341f
C1916 adc_dac0 vss 8.10014f
C1917 adc_mux3 vss 8.37183f
C1918 adc_mux2 vss 8.3579f
C1919 adc_mux1 vss 8.38446f
C1920 adc_mux0 vss 8.40949f
C1921 vtemp vss 6.14685f
C1922 clk_lf vss 52.74109f
C1923 bod_o vss 18.10828f
C1924 bod_level0 vss 11.05212f
C1925 por_n vss 27.26152f
C1926 clk_xa vss 25.09105f
C1927 clk_rc vss 19.52523f
C1928 rc_trim7 vss 6.39623f
C1929 rc_trim6 vss 6.41854f
C1930 rc_trim5 vss 6.44028f
C1931 rc_trim4 vss 6.46135f
C1932 rc_trim3 vss 6.48193f
C1933 rc_trim2 vss 6.48918f
C1934 rc_trim1 vss 6.49306f
C1935 rc_trim0 vss 7.02672f
C1936 rc_en vss 16.98788f
C1937 ok vss 40.54765f
C1938 vbp vss 0.25239p
C1939 aref vss 0.10559p
C1940 rv328_acsw_0/rv328_acsw_p0_0/gf180mcu_fd_sc_mcu9t5v0__inv_1_0/ZN vss 1.91874f
C1941 ac_mux_en vss 21.91256f
C1942 ain0 vss 4.24847f
C1943 acp vss 19.89145f
C1944 rv328_acsw_0/rv328_acsw_p0_0/gf180mcu_fd_sc_mcu9t5v0__inv_1_1/ZN vss 2.03867f
C1945 vref vss 0.12582p
C1946 ac_bg vss 48.82978f
C1947 ain1 vss 4.31056f
C1948 acm vss 10.42192f
C1949 amx vss 73.11813f
C1950 avdd vss 0.52236p
C1951 rv328_glue_0/rv328_glue_p0_0/gf180mcu_fd_sc_mcu9t5v0__nor2_1_1/a_234_573# vss 0 ; **FLOATING
C1952 bod_level2 vss 16.6287f
C1953 bod_level1 vss 12.16568f
C1954 rv328_glue_0/rv328_glue_p0_0/gf180mcu_fd_sc_mcu9t5v0__nor2_1_0/a_234_573# vss 0 ; **FLOATING
C1955 rv328_glue_0/rv328_glue_p0_0/gf180mcu_fd_sc_mcu9t5v0__inv_1_4/I vss 0.98296f
C1956 adc_refs0 vss 17.43025f
C1957 rv328_glue_0/rv328_glue_p0_0/gf180mcu_fd_sc_mcu9t5v0__nand3_1_1/a_455_69# vss 0.0135f ; **FLOATING
C1958 rv328_glue_0/rv328_glue_p0_0/gf180mcu_fd_sc_mcu9t5v0__nand3_1_1/a_271_69# vss 0.01255f ; **FLOATING
C1959 rv328_glue_0/rv328_glue_p0_0/gf180mcu_fd_sc_mcu9t5v0__nand3_1_0/a_455_69# vss 0.01384f ; **FLOATING
C1960 rv328_glue_0/rv328_glue_p0_0/gf180mcu_fd_sc_mcu9t5v0__nand3_1_0/a_271_69# vss 0.01181f ; **FLOATING
C1961 rv328_glue_0/rv328_glue_p0_0/gf180mcu_fd_sc_mcu9t5v0__inv_1_8/ZN vss 1.0371f
C1962 lv1 vss 21.07916f
C1963 rv328_glue_0/rv328_glue_p0_0/gf180mcu_fd_sc_mcu9t5v0__inv_1_7/I vss 1.19125f
C1964 rv328_glue_0/rv328_glue_p0_0/gf180mcu_fd_sc_mcu9t5v0__inv_1_6/ZN vss 0.82089f
C1965 rv328_glue_0/rv328_glue_p0_0/gf180mcu_fd_sc_mcu9t5v0__inv_1_5/ZN vss 1.06129f
C1966 adc_refs1 vss 13.95339f
C1967 en_buf vss 22.19574f
C1968 en_avcc vss 15.86915f
C1969 rv328_glue_0/rv328_glue_p0_0/gf180mcu_fd_sc_mcu9t5v0__inv_1_3/I vss 1.35372f
C1970 adc_cmp vss 24.32505f
C1971 rv328_glue_0/rv328_glue_p0_0/gf180mcu_fd_sc_mcu9t5v0__inv_1_1/I vss 1.10362f
C1972 smp vss 85.85616f
C1973 ac_out vss 13.92719f
C1974 xo_mode1 vss 24.06199f
C1975 xo_mode0 vss 14.71628f
C1976 rv328_glue_0/rv328_glue_p0_0/gf180mcu_fd_sc_mcu9t5v0__nand2_1_7/a_245_69# vss 0.0105f ; **FLOATING
C1977 rv328_glue_0/rv328_glue_p0_0/gf180mcu_fd_sc_mcu9t5v0__inv_1_8/I vss 1.01419f
C1978 xo_en vss 32.4239f
C1979 rv328_glue_0/rv328_glue_p0_0/gf180mcu_fd_sc_mcu9t5v0__nand2_1_7/ZN vss 1.27576f
C1980 rv328_glue_0/rv328_glue_p0_0/gf180mcu_fd_sc_mcu9t5v0__nand2_1_6/a_245_69# vss 0.0105f ; **FLOATING
C1981 bg_en vss 15.32733f
C1982 rv328_glue_0/rv328_glue_p0_0/gf180mcu_fd_sc_mcu9t5v0__nor2_1_1/ZN vss 0.89674f
C1983 rv328_glue_0/rv328_glue_p0_0/gf180mcu_fd_sc_mcu9t5v0__nand2_1_5/a_245_69# vss 0.01034f ; **FLOATING
C1984 rv328_glue_0/rv328_glue_p0_0/gf180mcu_fd_sc_mcu9t5v0__nand2_1_4/ZN vss 1.03599f
C1985 ac_en vss 75.75102f
C1986 rv328_glue_0/rv328_glue_p0_0/gf180mcu_fd_sc_mcu9t5v0__nand2_1_4/a_245_69# vss 0.01039f ; **FLOATING
C1987 mux_en vss 24.03171f
C1988 rv328_glue_0/rv328_glue_p0_0/gf180mcu_fd_sc_mcu9t5v0__nand2_1_3/a_245_69# vss 0.01022f ; **FLOATING
C1989 rv328_glue_0/rv328_glue_p0_0/gf180mcu_fd_sc_mcu9t5v0__inv_1_2/I vss 1.17284f
C1990 adc_sample vss 28.52473f
C1991 rv328_glue_0/rv328_glue_p0_0/gf180mcu_fd_sc_mcu9t5v0__nand2_1_2/a_245_69# vss 0.01047f ; **FLOATING
C1992 cmpa vss 40.32091f
C1993 rv328_glue_0/rv328_glue_p0_0/gf180mcu_fd_sc_mcu9t5v0__nand2_1_1/a_245_69# vss 0.01022f ; **FLOATING
C1994 rv328_glue_0/rv328_glue_p0_0/gf180mcu_fd_sc_mcu9t5v0__inv_1_0/I vss 1.62551f
C1995 aco vss 49.55389f
C1996 rv328_glue_0/rv328_glue_p0_0/gf180mcu_fd_sc_mcu9t5v0__nand2_1_0/a_245_69# vss 0.01017f ; **FLOATING
C1997 rv328_glue_0/rv328_glue_p0_0/gf180mcu_fd_sc_mcu9t5v0__nor2_1_2/ZN vss 0.81139f
C1998 bod_en vss 52.0481f
C1999 adc_en vss 63.45851f
C2000 rv328_glue_0/rv328_glue_p0_0/gf180mcu_fd_sc_mcu9t5v0__nor2_1_2/a_234_573# vss 0.00194f ; **FLOATING
* --- the blocks
xpor avdd vss por_n rv328_por
xlf  avdd vss clk_lf rv328_lfosc
xbgr avdd vss bg_en vref vbp ok rv328_bgr
xbod avdd vss bod_en lv1 bod_level0 vref vbp ok bod_o rv328_bod
xrc avdd vss rc_en rc_trim7 rc_trim6 rc_trim5 rc_trim4 rc_trim3 rc_trim2 rc_trim1 rc_trim0 clk_rc rv328_rcosc
xxo avdd vss xo_en xo_mode1 xo_mode0 xtal1 xtal2 vbp clk_xa rv328_xosc
xts  avdd vss adc_en vbp vtemp rv328_tsens
xmux avdd vss adc7 adc6 adc5 adc4 adc3 adc2 adc1 adc0 vtemp vref adc_mux3 adc_mux2 adc_mux1 adc_mux0 mux_en amx rv328_amux
xrb  avdd vss en_buf en_avcc vref vbp aref rv328_refbuf
xfe  avdd vss amx aref smp adc_dac9 adc_dac8 adc_dac7 adc_dac6 adc_dac5 adc_dac4 adc_dac3 adc_dac2 adc_dac1 adc_dac0 vbp adc_en cmpa rv328_adcfe
xac  avdd vss acp acm aco vbp ac_en rv328_cmp mt=2
.ends
