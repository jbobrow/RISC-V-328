* rv328_analog with the wiring capacitance of its layout. Written by analog/layout/pex_block.py from rv328_analog.gds;
* same cell name and pins as the schematic. 2001 wiring capacitors, no wiring resistance;
* 89 transistor fingers; groups of 9 or more identical parallel ones are one line with m=.
* The blocks are the cells of analog/blocks (or their own extracted netlists, see sim.py); the gates and
* switches of the macro itself and the capacitance of the wiring between the blocks are from the layout.
* Not in here: capacitance between this wiring and the nodes inside a block.
* NGSPICE file created from rv328_analog.ext - technology: gf180mcuD

.subckt rv328_analog avdd vss xtal1 xtal2 aref adc7 adc6 adc5 adc4 adc3 adc2 adc1 adc0 ain0 ain1 clk_rc clk_xa clk_lf por_n bod_o rc_en rc_trim7 rc_trim6 rc_trim5 rc_trim4 rc_trim3 rc_trim2 rc_trim1 rc_trim0 xo_en xo_mode1 xo_mode0 bod_en bod_level2 bod_level1 bod_level0 adc_en adc_mux3 adc_mux2 adc_mux1 adc_mux0 adc_refs1 adc_refs0 adc_sample adc_dac9 adc_dac8 adc_dac7 adc_dac6 adc_dac5 adc_dac4 adc_dac3 adc_dac2 adc_dac1 adc_dac0 adc_cmp ac_en ac_bg ac_mux_en ac_out
X0 rv328_glue_0/rv328_glue_p0_0/gf180mcu_fd_sc_mcu9t5v0__nor2_1_2/ZN bod_en rv328_glue_0/rv328_glue_p0_0/gf180mcu_fd_sc_mcu9t5v0__nor2_1_2/a_234_573# avdd pfet_05v0 ad=0.8052p pd=4.54u as=0.5673p ps=2.45u w=1.83u l=0.5u
X1 vss bod_en rv328_glue_0/rv328_glue_p0_0/gf180mcu_fd_sc_mcu9t5v0__nor2_1_2/ZN vss nfet_05v0 ad=0.4048p pd=2.72u as=0.2392p ps=1.44u w=0.92u l=0.6u
X2 rv328_glue_0/rv328_glue_p0_0/gf180mcu_fd_sc_mcu9t5v0__nor2_1_2/a_234_573# adc_en avdd avdd pfet_05v0 ad=0.5673p pd=2.45u as=0.8052p ps=4.54u w=1.83u l=0.5u
X3 rv328_glue_0/rv328_glue_p0_0/gf180mcu_fd_sc_mcu9t5v0__nor2_1_2/ZN adc_en vss vss nfet_05v0 ad=0.2392p pd=1.44u as=0.4048p ps=2.72u w=0.92u l=0.6u
X4 rv328_glue_0/rv328_glue_p0_0/gf180mcu_fd_sc_mcu9t5v0__inv_1_0/I ac_en avdd avdd pfet_05v0 ad=0.4277p pd=2.165u as=0.7238p ps=4.17u w=1.645u l=0.5u
X5 avdd aco rv328_glue_0/rv328_glue_p0_0/gf180mcu_fd_sc_mcu9t5v0__inv_1_0/I avdd pfet_05v0 ad=0.7238p pd=4.17u as=0.4277p ps=2.165u w=1.645u l=0.5u
X6 rv328_glue_0/rv328_glue_p0_0/gf180mcu_fd_sc_mcu9t5v0__inv_1_0/I aco rv328_glue_0/rv328_glue_p0_0/gf180mcu_fd_sc_mcu9t5v0__nand2_1_0/a_245_69# vss nfet_05v0 ad=0.5808p pd=3.52u as=0.2112p ps=1.64u w=1.32u l=0.6u
X7 rv328_glue_0/rv328_glue_p0_0/gf180mcu_fd_sc_mcu9t5v0__nand2_1_0/a_245_69# ac_en vss vss nfet_05v0 ad=0.2112p pd=1.64u as=0.5808p ps=3.52u w=1.32u l=0.6u
X8 rv328_glue_0/rv328_glue_p0_0/gf180mcu_fd_sc_mcu9t5v0__inv_1_1/I adc_en avdd avdd pfet_05v0 ad=0.8554p pd=4.33u as=25.6568p ps=0.1458m w=1.645u l=0.5u
X9 avdd cmpa rv328_glue_0/rv328_glue_p0_0/gf180mcu_fd_sc_mcu9t5v0__inv_1_1/I avdd pfet_05v0 ad=0 pd=0 as=0 ps=0 w=1.645u l=0.5u
X10 rv328_glue_0/rv328_glue_p0_0/gf180mcu_fd_sc_mcu9t5v0__inv_1_1/I cmpa rv328_glue_0/rv328_glue_p0_0/gf180mcu_fd_sc_mcu9t5v0__nand2_1_1/a_245_69# vss nfet_05v0 ad=0.5808p pd=3.52u as=0.4224p ps=3.28u w=1.32u l=0.6u
X11 rv328_glue_0/rv328_glue_p0_0/gf180mcu_fd_sc_mcu9t5v0__nand2_1_1/a_245_69# adc_en vss vss nfet_05v0 ad=0 pd=0 as=14.6256p ps=90.24u w=1.32u l=0.6u
X12 rv328_glue_0/rv328_glue_p0_0/gf180mcu_fd_sc_mcu9t5v0__inv_1_2/I adc_en avdd avdd pfet_05v0 ad=0.8554p pd=4.33u as=0 ps=0 w=1.645u l=0.5u
X13 avdd adc_sample rv328_glue_0/rv328_glue_p0_0/gf180mcu_fd_sc_mcu9t5v0__inv_1_2/I avdd pfet_05v0 ad=0 pd=0 as=0 ps=0 w=1.645u l=0.5u
X14 rv328_glue_0/rv328_glue_p0_0/gf180mcu_fd_sc_mcu9t5v0__inv_1_2/I adc_sample rv328_glue_0/rv328_glue_p0_0/gf180mcu_fd_sc_mcu9t5v0__nand2_1_2/a_245_69# vss nfet_05v0 ad=0.5808p pd=3.52u as=0.4224p ps=3.28u w=1.32u l=0.6u
X15 rv328_glue_0/rv328_glue_p0_0/gf180mcu_fd_sc_mcu9t5v0__nand2_1_2/a_245_69# adc_en vss vss nfet_05v0 ad=0 pd=0 as=0 ps=0 w=1.32u l=0.6u
X16 mux_en rv328_glue_0/rv328_glue_p0_0/gf180mcu_fd_sc_mcu9t5v0__nand2_1_4/ZN avdd avdd pfet_05v0 ad=0.8554p pd=4.33u as=0 ps=0 w=1.645u l=0.5u
X17 avdd rv328_glue_0/rv328_glue_p0_0/gf180mcu_fd_sc_mcu9t5v0__inv_1_6/ZN mux_en avdd pfet_05v0 ad=0 pd=0 as=0 ps=0 w=1.645u l=0.5u
X18 mux_en rv328_glue_0/rv328_glue_p0_0/gf180mcu_fd_sc_mcu9t5v0__inv_1_6/ZN rv328_glue_0/rv328_glue_p0_0/gf180mcu_fd_sc_mcu9t5v0__nand2_1_3/a_245_69# vss nfet_05v0 ad=0.5808p pd=3.52u as=0.4224p ps=3.28u w=1.32u l=0.6u
X19 rv328_glue_0/rv328_glue_p0_0/gf180mcu_fd_sc_mcu9t5v0__nand2_1_3/a_245_69# rv328_glue_0/rv328_glue_p0_0/gf180mcu_fd_sc_mcu9t5v0__nand2_1_4/ZN vss vss nfet_05v0 ad=0 pd=0 as=0 ps=0 w=1.32u l=0.6u
X20 rv328_glue_0/rv328_glue_p0_0/gf180mcu_fd_sc_mcu9t5v0__nand2_1_4/ZN ac_mux_en avdd avdd pfet_05v0 ad=0.8554p pd=4.33u as=0 ps=0 w=1.645u l=0.5u
X21 avdd ac_en rv328_glue_0/rv328_glue_p0_0/gf180mcu_fd_sc_mcu9t5v0__nand2_1_4/ZN avdd pfet_05v0 ad=0 pd=0 as=0 ps=0 w=1.645u l=0.5u
X22 rv328_glue_0/rv328_glue_p0_0/gf180mcu_fd_sc_mcu9t5v0__nand2_1_4/ZN ac_en rv328_glue_0/rv328_glue_p0_0/gf180mcu_fd_sc_mcu9t5v0__nand2_1_4/a_245_69# vss nfet_05v0 ad=0.5808p pd=3.52u as=0.4224p ps=3.28u w=1.32u l=0.6u
X23 rv328_glue_0/rv328_glue_p0_0/gf180mcu_fd_sc_mcu9t5v0__nand2_1_4/a_245_69# ac_mux_en vss vss nfet_05v0 ad=0 pd=0 as=0 ps=0 w=1.32u l=0.6u
X24 bg_en rv328_glue_0/rv328_glue_p0_0/gf180mcu_fd_sc_mcu9t5v0__nor2_1_1/ZN avdd avdd pfet_05v0 ad=0.8554p pd=4.33u as=0 ps=0 w=1.645u l=0.5u
X25 avdd rv328_glue_0/rv328_glue_p0_0/gf180mcu_fd_sc_mcu9t5v0__nor2_1_2/ZN bg_en avdd pfet_05v0 ad=0 pd=0 as=0 ps=0 w=1.645u l=0.5u
X26 bg_en rv328_glue_0/rv328_glue_p0_0/gf180mcu_fd_sc_mcu9t5v0__nor2_1_2/ZN rv328_glue_0/rv328_glue_p0_0/gf180mcu_fd_sc_mcu9t5v0__nand2_1_5/a_245_69# vss nfet_05v0 ad=0.5808p pd=3.52u as=0.4224p ps=3.28u w=1.32u l=0.6u
X27 rv328_glue_0/rv328_glue_p0_0/gf180mcu_fd_sc_mcu9t5v0__nand2_1_5/a_245_69# rv328_glue_0/rv328_glue_p0_0/gf180mcu_fd_sc_mcu9t5v0__nor2_1_1/ZN vss vss nfet_05v0 ad=0 pd=0 as=0 ps=0 w=1.32u l=0.6u
X28 rv328_glue_0/rv328_glue_p0_0/gf180mcu_fd_sc_mcu9t5v0__inv_1_8/I rv328_glue_0/rv328_glue_p0_0/gf180mcu_fd_sc_mcu9t5v0__nand2_1_7/ZN avdd avdd pfet_05v0 ad=0.8554p pd=4.33u as=0 ps=0 w=1.645u l=0.5u
X29 avdd xo_en rv328_glue_0/rv328_glue_p0_0/gf180mcu_fd_sc_mcu9t5v0__inv_1_8/I avdd pfet_05v0 ad=0 pd=0 as=0 ps=0 w=1.645u l=0.5u
X30 rv328_glue_0/rv328_glue_p0_0/gf180mcu_fd_sc_mcu9t5v0__inv_1_8/I xo_en rv328_glue_0/rv328_glue_p0_0/gf180mcu_fd_sc_mcu9t5v0__nand2_1_6/a_245_69# vss nfet_05v0 ad=0.5808p pd=3.52u as=0.4224p ps=3.28u w=1.32u l=0.6u
X31 rv328_glue_0/rv328_glue_p0_0/gf180mcu_fd_sc_mcu9t5v0__nand2_1_6/a_245_69# rv328_glue_0/rv328_glue_p0_0/gf180mcu_fd_sc_mcu9t5v0__nand2_1_7/ZN vss vss nfet_05v0 ad=0 pd=0 as=0 ps=0 w=1.32u l=0.6u
X32 rv328_glue_0/rv328_glue_p0_0/gf180mcu_fd_sc_mcu9t5v0__nand2_1_7/ZN xo_mode0 avdd avdd pfet_05v0 ad=0.8554p pd=4.33u as=0 ps=0 w=1.645u l=0.5u
X33 avdd xo_mode1 rv328_glue_0/rv328_glue_p0_0/gf180mcu_fd_sc_mcu9t5v0__nand2_1_7/ZN avdd pfet_05v0 ad=0 pd=0 as=0 ps=0 w=1.645u l=0.5u
X34 rv328_glue_0/rv328_glue_p0_0/gf180mcu_fd_sc_mcu9t5v0__nand2_1_7/ZN xo_mode1 rv328_glue_0/rv328_glue_p0_0/gf180mcu_fd_sc_mcu9t5v0__nand2_1_7/a_245_69# vss nfet_05v0 ad=0.5808p pd=3.52u as=0.4224p ps=3.28u w=1.32u l=0.6u
X35 rv328_glue_0/rv328_glue_p0_0/gf180mcu_fd_sc_mcu9t5v0__nand2_1_7/a_245_69# xo_mode0 vss vss nfet_05v0 ad=0 pd=0 as=0 ps=0 w=1.32u l=0.6u
X36 ac_out rv328_glue_0/rv328_glue_p0_0/gf180mcu_fd_sc_mcu9t5v0__inv_1_0/I avdd avdd pfet_05v0 ad=0.8052p pd=4.54u as=0.8052p ps=4.54u w=1.83u l=0.5u
X37 ac_out rv328_glue_0/rv328_glue_p0_0/gf180mcu_fd_sc_mcu9t5v0__inv_1_0/I vss vss nfet_05v0 ad=0.5808p pd=3.52u as=0.5808p ps=3.52u w=1.32u l=0.6u
X38 smp rv328_glue_0/rv328_glue_p0_0/gf180mcu_fd_sc_mcu9t5v0__inv_1_2/I avdd avdd pfet_05v0 ad=0.8052p pd=4.54u as=0 ps=0 w=1.83u l=0.5u
X39 smp rv328_glue_0/rv328_glue_p0_0/gf180mcu_fd_sc_mcu9t5v0__inv_1_2/I vss vss nfet_05v0 ad=0.5808p pd=3.52u as=0 ps=0 w=1.32u l=0.6u
X40 adc_cmp rv328_glue_0/rv328_glue_p0_0/gf180mcu_fd_sc_mcu9t5v0__inv_1_1/I avdd avdd pfet_05v0 ad=0.8052p pd=4.54u as=0 ps=0 w=1.83u l=0.5u
X41 adc_cmp rv328_glue_0/rv328_glue_p0_0/gf180mcu_fd_sc_mcu9t5v0__inv_1_1/I vss vss nfet_05v0 ad=0.5808p pd=3.52u as=0 ps=0 w=1.32u l=0.6u
X42 en_avcc rv328_glue_0/rv328_glue_p0_0/gf180mcu_fd_sc_mcu9t5v0__inv_1_3/I avdd avdd pfet_05v0 ad=0.8052p pd=4.54u as=0 ps=0 w=1.83u l=0.5u
X43 en_avcc rv328_glue_0/rv328_glue_p0_0/gf180mcu_fd_sc_mcu9t5v0__inv_1_3/I vss vss nfet_05v0 ad=0.5808p pd=3.52u as=0 ps=0 w=1.32u l=0.6u
X44 en_buf rv328_glue_0/rv328_glue_p0_0/gf180mcu_fd_sc_mcu9t5v0__inv_1_4/I avdd avdd pfet_05v0 ad=0.8052p pd=4.54u as=0 ps=0 w=1.83u l=0.5u
X45 en_buf rv328_glue_0/rv328_glue_p0_0/gf180mcu_fd_sc_mcu9t5v0__inv_1_4/I vss vss nfet_05v0 ad=0.5808p pd=3.52u as=0 ps=0 w=1.32u l=0.6u
X46 rv328_glue_0/rv328_glue_p0_0/gf180mcu_fd_sc_mcu9t5v0__inv_1_5/ZN adc_refs1 avdd avdd pfet_05v0 ad=0.8052p pd=4.54u as=0 ps=0 w=1.83u l=0.5u
X47 rv328_glue_0/rv328_glue_p0_0/gf180mcu_fd_sc_mcu9t5v0__inv_1_5/ZN adc_refs1 vss vss nfet_05v0 ad=0.5808p pd=3.52u as=0 ps=0 w=1.32u l=0.6u
X48 rv328_glue_0/rv328_glue_p0_0/gf180mcu_fd_sc_mcu9t5v0__inv_1_6/ZN adc_en avdd avdd pfet_05v0 ad=0.8052p pd=4.54u as=0 ps=0 w=1.83u l=0.5u
X49 rv328_glue_0/rv328_glue_p0_0/gf180mcu_fd_sc_mcu9t5v0__inv_1_6/ZN adc_en vss vss nfet_05v0 ad=0.5808p pd=3.52u as=0 ps=0 w=1.32u l=0.6u
X50 lv1 rv328_glue_0/rv328_glue_p0_0/gf180mcu_fd_sc_mcu9t5v0__inv_1_7/I avdd avdd pfet_05v0 ad=0.8052p pd=4.54u as=0 ps=0 w=1.83u l=0.5u
X51 lv1 rv328_glue_0/rv328_glue_p0_0/gf180mcu_fd_sc_mcu9t5v0__inv_1_7/I vss vss nfet_05v0 ad=0.5808p pd=3.52u as=0 ps=0 w=1.32u l=0.6u
X52 rv328_glue_0/rv328_glue_p0_0/gf180mcu_fd_sc_mcu9t5v0__inv_1_8/ZN rv328_glue_0/rv328_glue_p0_0/gf180mcu_fd_sc_mcu9t5v0__inv_1_8/I avdd avdd pfet_05v0 ad=0.8052p pd=4.54u as=0 ps=0 w=1.83u l=0.5u
X53 rv328_glue_0/rv328_glue_p0_0/gf180mcu_fd_sc_mcu9t5v0__inv_1_8/ZN rv328_glue_0/rv328_glue_p0_0/gf180mcu_fd_sc_mcu9t5v0__inv_1_8/I vss vss nfet_05v0 ad=0.5808p pd=3.52u as=0 ps=0 w=1.32u l=0.6u
X54 avdd rv328_glue_0/rv328_glue_p0_0/gf180mcu_fd_sc_mcu9t5v0__inv_1_5/ZN rv328_glue_0/rv328_glue_p0_0/gf180mcu_fd_sc_mcu9t5v0__inv_1_3/I avdd pfet_05v0 ad=0.3796p pd=1.98u as=0.3796p ps=1.98u w=1.46u l=0.5u
X55 rv328_glue_0/rv328_glue_p0_0/gf180mcu_fd_sc_mcu9t5v0__nand3_1_0/a_271_69# adc_refs0 vss vss nfet_05v0 ad=0.2112p pd=1.64u as=0.5808p ps=3.52u w=1.32u l=0.6u
X56 rv328_glue_0/rv328_glue_p0_0/gf180mcu_fd_sc_mcu9t5v0__nand3_1_0/a_455_69# rv328_glue_0/rv328_glue_p0_0/gf180mcu_fd_sc_mcu9t5v0__inv_1_5/ZN rv328_glue_0/rv328_glue_p0_0/gf180mcu_fd_sc_mcu9t5v0__nand3_1_0/a_271_69# vss nfet_05v0 ad=0.2772p pd=1.74u as=0.2112p ps=1.64u w=1.32u l=0.6u
X57 rv328_glue_0/rv328_glue_p0_0/gf180mcu_fd_sc_mcu9t5v0__inv_1_3/I adc_en avdd avdd pfet_05v0 ad=0.6424p pd=3.8u as=0.3796p ps=1.98u w=1.46u l=0.5u
X58 rv328_glue_0/rv328_glue_p0_0/gf180mcu_fd_sc_mcu9t5v0__inv_1_3/I adc_en rv328_glue_0/rv328_glue_p0_0/gf180mcu_fd_sc_mcu9t5v0__nand3_1_0/a_455_69# vss nfet_05v0 ad=0.5808p pd=3.52u as=0.2772p ps=1.74u w=1.32u l=0.6u
X59 rv328_glue_0/rv328_glue_p0_0/gf180mcu_fd_sc_mcu9t5v0__inv_1_3/I adc_refs0 avdd avdd pfet_05v0 ad=0.3796p pd=1.98u as=0.6424p ps=3.8u w=1.46u l=0.5u
X60 avdd adc_refs1 rv328_glue_0/rv328_glue_p0_0/gf180mcu_fd_sc_mcu9t5v0__inv_1_4/I avdd pfet_05v0 ad=0 pd=0 as=1.4016p ps=7.76u w=1.46u l=0.5u
X61 rv328_glue_0/rv328_glue_p0_0/gf180mcu_fd_sc_mcu9t5v0__nand3_1_1/a_271_69# adc_refs0 vss vss nfet_05v0 ad=0.4224p pd=3.28u as=0 ps=0 w=1.32u l=0.6u
X62 rv328_glue_0/rv328_glue_p0_0/gf180mcu_fd_sc_mcu9t5v0__nand3_1_1/a_455_69# adc_refs1 rv328_glue_0/rv328_glue_p0_0/gf180mcu_fd_sc_mcu9t5v0__nand3_1_1/a_271_69# vss nfet_05v0 ad=0.5544p pd=3.48u as=0 ps=0 w=1.32u l=0.6u
X63 rv328_glue_0/rv328_glue_p0_0/gf180mcu_fd_sc_mcu9t5v0__inv_1_4/I adc_en avdd avdd pfet_05v0 ad=0 pd=0 as=0 ps=0 w=1.46u l=0.5u
X64 rv328_glue_0/rv328_glue_p0_0/gf180mcu_fd_sc_mcu9t5v0__inv_1_4/I adc_en rv328_glue_0/rv328_glue_p0_0/gf180mcu_fd_sc_mcu9t5v0__nand3_1_1/a_455_69# vss nfet_05v0 ad=0.5808p pd=3.52u as=0 ps=0 w=1.32u l=0.6u
X65 rv328_glue_0/rv328_glue_p0_0/gf180mcu_fd_sc_mcu9t5v0__inv_1_4/I adc_refs0 avdd avdd pfet_05v0 ad=0 pd=0 as=0 ps=0 w=1.46u l=0.5u
X66 rv328_glue_0/rv328_glue_p0_0/gf180mcu_fd_sc_mcu9t5v0__inv_1_7/I bod_level2 rv328_glue_0/rv328_glue_p0_0/gf180mcu_fd_sc_mcu9t5v0__nor2_1_0/a_234_573# avdd pfet_05v0 ad=0.8052p pd=4.54u as=1.1346p ps=4.9u w=1.83u l=0.5u
X67 vss bod_level2 rv328_glue_0/rv328_glue_p0_0/gf180mcu_fd_sc_mcu9t5v0__inv_1_7/I vss nfet_05v0 ad=0 pd=0 as=0.4784p ps=2.88u w=0.92u l=0.6u
X68 rv328_glue_0/rv328_glue_p0_0/gf180mcu_fd_sc_mcu9t5v0__nor2_1_0/a_234_573# bod_level1 avdd avdd pfet_05v0 ad=0 pd=0 as=0 ps=0 w=1.83u l=0.5u
X69 rv328_glue_0/rv328_glue_p0_0/gf180mcu_fd_sc_mcu9t5v0__inv_1_7/I bod_level1 vss vss nfet_05v0 ad=0 pd=0 as=0 ps=0 w=0.92u l=0.6u
X70 rv328_glue_0/rv328_glue_p0_0/gf180mcu_fd_sc_mcu9t5v0__nor2_1_1/ZN ac_en rv328_glue_0/rv328_glue_p0_0/gf180mcu_fd_sc_mcu9t5v0__nor2_1_1/a_234_573# avdd pfet_05v0 ad=0.8052p pd=4.54u as=1.1346p ps=4.9u w=1.83u l=0.5u
X71 vss ac_en rv328_glue_0/rv328_glue_p0_0/gf180mcu_fd_sc_mcu9t5v0__nor2_1_1/ZN vss nfet_05v0 ad=0 pd=0 as=0.4784p ps=2.88u w=0.92u l=0.6u
X72 rv328_glue_0/rv328_glue_p0_0/gf180mcu_fd_sc_mcu9t5v0__nor2_1_1/a_234_573# rv328_glue_0/rv328_glue_p0_0/gf180mcu_fd_sc_mcu9t5v0__inv_1_8/ZN avdd avdd pfet_05v0 ad=0 pd=0 as=0 ps=0 w=1.83u l=0.5u
X73 rv328_glue_0/rv328_glue_p0_0/gf180mcu_fd_sc_mcu9t5v0__nor2_1_1/ZN rv328_glue_0/rv328_glue_p0_0/gf180mcu_fd_sc_mcu9t5v0__inv_1_8/ZN vss vss nfet_05v0 ad=0 pd=0 as=0 ps=0 w=0.92u l=0.6u
X74 amx ac_mux_en acm vss nfet_06v0 ad=5p pd=21u as=5p ps=21u w=10u l=0.7u
X75 ain1 rv328_acsw_0/rv328_acsw_p0_0/gf180mcu_fd_sc_mcu9t5v0__inv_1_0/ZN acm vss nfet_06v0 ad=5p pd=21u as=10p ps=42u w=10u l=0.7u
X76 vref ac_bg acp vss nfet_06v0 ad=1p pd=5u as=1p ps=5u w=2u l=0.7u
X77 ain0 rv328_acsw_0/rv328_acsw_p0_0/gf180mcu_fd_sc_mcu9t5v0__inv_1_1/ZN acp vss nfet_06v0 ad=5p pd=21u as=6p ps=26u w=10u l=0.7u
X78 amx rv328_acsw_0/rv328_acsw_p0_0/gf180mcu_fd_sc_mcu9t5v0__inv_1_0/ZN acm avdd pfet_06v0 ad=2.8p pd=10.56u as=5p ps=21u w=10u l=0.55u
X79 acm rv328_acsw_0/rv328_acsw_p0_0/gf180mcu_fd_sc_mcu9t5v0__inv_1_0/ZN amx avdd pfet_06v0 ad=5p pd=21u as=2.8p ps=10.56u w=10u l=0.55u
X80 ain1 ac_mux_en acm avdd pfet_06v0 ad=5.6p pd=21.12u as=20p ps=84u w=10u l=0.55u
X81 acm ac_mux_en ain1 avdd pfet_06v0 ad=0 pd=0 as=0 ps=0 w=10u l=0.55u
X82 ain0 ac_bg acp avdd pfet_06v0 ad=5.6p pd=21.12u as=12p ps=51u w=10u l=0.55u
X83 acp ac_bg ain0 avdd pfet_06v0 ad=0 pd=0 as=0 ps=0 w=10u l=0.55u
X84 vref rv328_acsw_0/rv328_acsw_p0_0/gf180mcu_fd_sc_mcu9t5v0__inv_1_1/ZN acp avdd pfet_06v0 ad=2p pd=9u as=2p ps=9u w=4u l=0.55u
X85 rv328_acsw_0/rv328_acsw_p0_0/gf180mcu_fd_sc_mcu9t5v0__inv_1_0/ZN ac_mux_en avdd avdd pfet_05v0 ad=0.8052p pd=4.54u as=0 ps=0 w=1.83u l=0.5u
X86 rv328_acsw_0/rv328_acsw_p0_0/gf180mcu_fd_sc_mcu9t5v0__inv_1_0/ZN ac_mux_en vss vss nfet_05v0 ad=0.5808p pd=3.52u as=0 ps=0 w=1.32u l=0.6u
X87 rv328_acsw_0/rv328_acsw_p0_0/gf180mcu_fd_sc_mcu9t5v0__inv_1_1/ZN ac_bg avdd avdd pfet_05v0 ad=0.8052p pd=4.54u as=0 ps=0 w=1.83u l=0.5u
X88 rv328_acsw_0/rv328_acsw_p0_0/gf180mcu_fd_sc_mcu9t5v0__inv_1_1/ZN ac_bg vss vss nfet_05v0 ad=0.5808p pd=3.52u as=0 ps=0 w=1.32u l=0.6u
C0 adc6 vbp 0.04646f
C1 vref ain1 0.3803f
C2 rv328_glue_0/rv328_glue_p0_0/gf180mcu_fd_sc_mcu9t5v0__inv_1_3/I ac_out 0.02486f
C3 adc_dac0 adc_dac7 0.04062f
C4 adc5 aco 0.05164f
C5 rv328_glue_0/rv328_glue_p0_0/gf180mcu_fd_sc_mcu9t5v0__inv_1_5/ZN rv328_glue_0/rv328_glue_p0_0/gf180mcu_fd_sc_mcu9t5v0__nand2_1_4/ZN 0.11628f
C6 rv328_glue_0/rv328_glue_p0_0/gf180mcu_fd_sc_mcu9t5v0__nor2_1_1/ZN rv328_glue_0/rv328_glue_p0_0/gf180mcu_fd_sc_mcu9t5v0__nand2_1_5/a_245_69# 0
C7 adc4 avdd 0.4361f
C8 avdd bg_en 0.42137f
C9 amx clk_xa 0.05772f
C10 cmpa adc_mux0 0.08564f
C11 adc_en rv328_glue_0/rv328_glue_p0_0/gf180mcu_fd_sc_mcu9t5v0__inv_1_0/I 0
C12 adc_mux0 xo_en 0.04044f
C13 adc_mux1 clk_xa 0.04044f
C14 lv1 rc_trim0 0.09543f
C15 rv328_glue_0/rv328_glue_p0_0/gf180mcu_fd_sc_mcu9t5v0__inv_1_7/I adc_refs1 0.02018f
C16 avdd rv328_glue_0/rv328_glue_p0_0/gf180mcu_fd_sc_mcu9t5v0__nor2_1_1/a_234_573# 0.02876f
C17 ac_mux_en ac_en 0.12p
C18 aco acp 1.19114f
C19 ac_bg xo_mode1 0.04436f
C20 adc_cmp adc_mux2 0.04908f
C21 clk_rc ac_out 0.06055f
C22 adc_refs1 rv328_glue_0/rv328_glue_p0_0/gf180mcu_fd_sc_mcu9t5v0__nand2_1_7/ZN 0.02045f
C23 aco rv328_glue_0/rv328_glue_p0_0/gf180mcu_fd_sc_mcu9t5v0__inv_1_2/I 0.01498f
C24 adc_sample rv328_glue_0/rv328_glue_p0_0/gf180mcu_fd_sc_mcu9t5v0__inv_1_5/ZN 0.03495f
C25 smp mux_en 7.2267f
C26 ac_en adc_dac4 0.04044f
C27 adc_mux2 adc1 0.04044f
C28 adc_en en_avcc 0.12979f
C29 ac_mux_en por_n 0.04044f
C30 adc_dac8 adc_dac9 42.208f
C31 vbp rc_trim1 0.13938f
C32 rv328_glue_0/rv328_glue_p0_0/gf180mcu_fd_sc_mcu9t5v0__inv_1_7/I lv1 1.51652f
C33 adc_refs0 rc_trim3 0.04044f
C34 vref xo_mode1 0.2101f
C35 adc_cmp adc_en 6.18453f
C36 ac_bg rc_trim0 0.043f
C37 adc_dac2 avdd 1.00164f
C38 adc_dac3 rc_trim1 0.04044f
C39 smp aref 0.49858f
C40 lv1 rv328_glue_0/rv328_glue_p0_0/gf180mcu_fd_sc_mcu9t5v0__nand2_1_7/ZN 0.02057f
C41 adc_en adc1 0.04044f
C42 en_buf xo_en 0.02074f
C43 cmpa en_buf 0.09523f
C44 adc_refs1 rv328_glue_0/rv328_glue_p0_0/gf180mcu_fd_sc_mcu9t5v0__inv_1_4/I 0.96036f
C45 avdd rv328_glue_0/rv328_glue_p0_0/gf180mcu_fd_sc_mcu9t5v0__nand2_1_4/ZN 0.48996f
C46 ac_mux_en amx 1.11486f
C47 rv328_glue_0/rv328_glue_p0_0/gf180mcu_fd_sc_mcu9t5v0__inv_1_3/I en_avcc 1.42508f
C48 rc_en adc_mux3 0.04548f
C49 ac_mux_en adc_mux1 0.04122f
C50 vref rc_trim0 0.16003f
C51 rv328_glue_0/rv328_glue_p0_0/gf180mcu_fd_sc_mcu9t5v0__inv_1_3/I adc_cmp 0.02082f
C52 adc_dac8 cmpa 0.1174f
C53 aref adc_dac0 0.25944f
C54 adc_dac8 xo_en 0.04044f
C55 adc_dac4 amx 0.04709f
C56 adc_dac4 adc_mux1 0.04044f
C57 rc_trim7 rc_trim3 0.04088f
C58 bod_level1 rv328_glue_0/rv328_glue_p0_0/gf180mcu_fd_sc_mcu9t5v0__inv_1_8/ZN 0.00653f
C59 adc7 aco 0.06028f
C60 bod_level0 ac_out 0.04179f
C61 vtemp ain1 0.05653f
C62 ac_mux_en rv328_glue_0/rv328_glue_p0_0/gf180mcu_fd_sc_mcu9t5v0__nor2_1_2/ZN 0.0348f
C63 rv328_glue_0/rv328_glue_p0_0/gf180mcu_fd_sc_mcu9t5v0__inv_1_1/I rv328_glue_0/rv328_glue_p0_0/gf180mcu_fd_sc_mcu9t5v0__nand2_1_1/a_245_69# 0.0162f
C64 adc_sample avdd 1.92915f
C65 vbp adc_mux0 0.04646f
C66 rv328_glue_0/rv328_glue_p0_0/gf180mcu_fd_sc_mcu9t5v0__inv_1_7/I vref 0
C67 adc_en rv328_glue_0/rv328_glue_p0_0/gf180mcu_fd_sc_mcu9t5v0__inv_1_5/ZN 0.15289f
C68 adc_cmp clk_rc 0.05881f
C69 adc_mux0 adc_dac3 0.04044f
C70 avdd rc_trim5 0.55046f
C71 ac_bg rv328_acsw_0/rv328_acsw_p0_0/gf180mcu_fd_sc_mcu9t5v0__inv_1_0/ZN 0
C72 adc_refs1 bod_en 49.6166f
C73 bod_level1 rc_trim3 0.04044f
C74 ac_en rc_en 0.09608f
C75 en_buf rv328_glue_0/rv328_glue_p0_0/gf180mcu_fd_sc_mcu9t5v0__nor2_1_1/ZN 0.02043f
C76 clk_lf adc_mux3 0.05771f
C77 smp adc_refs0 0.12919f
C78 rv328_glue_0/rv328_glue_p0_0/gf180mcu_fd_sc_mcu9t5v0__inv_1_3/I rv328_glue_0/rv328_glue_p0_0/gf180mcu_fd_sc_mcu9t5v0__inv_1_5/ZN 0.78861f
C79 vref rv328_acsw_0/rv328_acsw_p0_0/gf180mcu_fd_sc_mcu9t5v0__inv_1_0/ZN 0.04776f
C80 bod_en lv1 0.14034f
C81 xo_mode0 rv328_glue_0/rv328_glue_p0_0/gf180mcu_fd_sc_mcu9t5v0__nand2_1_7/a_245_69# 0
C82 ac_out adc_dac5 0.04683f
C83 avdd adc_mux2 1.35095f
C84 en_avcc xo_mode0 0
C85 adc_refs0 adc_dac0 0.04608f
C86 vbp en_buf 2.693f
C87 amx rc_en 0.06276f
C88 ok rc_trim3 0.0898f
C89 rv328_glue_0/rv328_glue_p0_0/gf180mcu_fd_sc_mcu9t5v0__nand3_1_1/a_455_69# rv328_glue_0/rv328_glue_p0_0/gf180mcu_fd_sc_mcu9t5v0__inv_1_5/ZN 0
C90 rc_en adc_mux1 0.04548f
C91 adc_dac8 vbp 0.04613f
C92 adc_cmp bod_level0 0.04908f
C93 smp rc_trim7 0.04844f
C94 adc_dac9 rc_trim2 0.0452f
C95 adc_en avdd 18.07006f
C96 ac_mux_en adc_dac1 0.04044f
C97 adc_en ain0 0.05633f
C98 adc_dac9 adc_dac6 0.0462f
C99 adc_dac8 adc_dac3 0.0408f
C100 ac_bg bod_en 0.043f
C101 adc5 adc_mux3 0.04044f
C102 ac_en clk_lf 0.05771f
C103 adc_dac4 adc_dac1 0.04144f
C104 adc3 avdd 0.4361f
C105 adc_en rv328_glue_0/rv328_glue_p0_0/gf180mcu_fd_sc_mcu9t5v0__nand3_1_0/a_271_69# 0.00139f
C106 rc_trim7 adc_dac0 0.04608f
C107 rv328_glue_0/rv328_glue_p0_0/gf180mcu_fd_sc_mcu9t5v0__inv_1_8/ZN bod_level2 0
C108 rv328_glue_0/rv328_glue_p0_0/gf180mcu_fd_sc_mcu9t5v0__inv_1_3/I avdd 0.89398f
C109 rc_trim2 xo_en 0.01423f
C110 cmpa rc_trim2 0.0452f
C111 vref bod_en 0.15748f
C112 smp bod_level1 0.11648f
C113 por_n clk_lf 0.05384f
C114 smp aco 0.11029f
C115 adc_dac9 rc_trim6 0.0452f
C116 rv328_glue_0/rv328_glue_p0_0/gf180mcu_fd_sc_mcu9t5v0__inv_1_1/I adc_sample 0.17484f
C117 rv328_glue_0/rv328_glue_p0_0/gf180mcu_fd_sc_mcu9t5v0__nor2_1_0/a_234_573# avdd 0.02898f
C118 adc_dac6 xo_en 0.04044f
C119 adc_dac6 cmpa 0.12103f
C120 cmpa rv328_glue_0/rv328_glue_p0_0/gf180mcu_fd_sc_mcu9t5v0__inv_1_8/I 0.01437f
C121 rv328_glue_0/rv328_glue_p0_0/gf180mcu_fd_sc_mcu9t5v0__inv_1_3/I rv328_glue_0/rv328_glue_p0_0/gf180mcu_fd_sc_mcu9t5v0__nand3_1_0/a_271_69# 0.00232f
C122 adc_dac9 adc_dac7 0.04736f
C123 adc_mux3 acp 0
C124 xo_mode1 bg_en 0.04054f
C125 rv328_glue_0/rv328_glue_p0_0/gf180mcu_fd_sc_mcu9t5v0__inv_1_8/I xo_en 1.91149f
C126 adc_refs1 lv1 0.05984f
C127 rv328_glue_0/rv328_glue_p0_0/gf180mcu_fd_sc_mcu9t5v0__nand3_1_1/a_455_69# avdd 0
C128 rc_trim3 bod_level2 0.04695f
C129 rc_trim4 rc_trim3 37.6965f
C130 amx clk_lf 0.06636f
C131 aco adc_dac0 0.18722f
C132 bod_level1 adc_dac0 0.04608f
C133 clk_rc avdd 2.02061f
C134 adc_cmp adc_dac5 0.04548f
C135 clk_lf adc_mux1 0.05771f
C136 rv328_acsw_0/rv328_acsw_p0_0/gf180mcu_fd_sc_mcu9t5v0__inv_1_1/ZN acp 0.99946f
C137 ac_en adc5 0.04044f
C138 cmpa rc_trim6 0.0452f
C139 rc_trim6 xo_en 0.04335f
C140 smp bod_o 0.09547f
C141 ok smp 0.04939f
C142 xo_en adc_dac7 0.04044f
C143 cmpa adc_dac7 0.119f
C144 adc_refs1 ac_bg 0.043f
C145 adc2 adc1 12.0687f
C146 adc0 adc_mux0 0.04853f
C147 adc_dac2 xo_mode1 0.04179f
C148 ac_mux_en clk_xa 0.09793f
C149 ac_en acp 0.04736f
C150 adc_dac1 rc_en 0.04804f
C151 rv328_glue_0/rv328_glue_p0_0/gf180mcu_fd_sc_mcu9t5v0__inv_1_7/I bg_en 0.03736f
C152 adc7 adc_mux3 0.04908f
C153 adc_refs1 vref 0.15244f
C154 ac_en rv328_glue_0/rv328_glue_p0_0/gf180mcu_fd_sc_mcu9t5v0__inv_1_2/I 0.01915f
C155 adc5 amx 0.05772f
C156 rv328_glue_0/rv328_glue_p0_0/gf180mcu_fd_sc_mcu9t5v0__nand2_1_7/ZN bg_en 0.02046f
C157 rv328_glue_0/rv328_glue_p0_0/gf180mcu_fd_sc_mcu9t5v0__inv_1_8/I rv328_glue_0/rv328_glue_p0_0/gf180mcu_fd_sc_mcu9t5v0__nor2_1_1/ZN 0
C158 rv328_glue_0/rv328_glue_p0_0/gf180mcu_fd_sc_mcu9t5v0__inv_1_1/I adc_en 0.71257f
C159 avdd xo_mode0 1.32105f
C160 adc_dac2 rc_trim0 0.04044f
C161 adc5 adc_mux1 0.04044f
C162 ac_out adc_mux0 0.04179f
C163 adc_dac9 aref 0.30138f
C164 bod_level0 avdd 1.32423f
C165 vbp rc_trim2 0.13938f
C166 vref lv1 0.09989f
C167 rv328_glue_0/rv328_glue_p0_0/gf180mcu_fd_sc_mcu9t5v0__inv_1_1/I rv328_glue_0/rv328_glue_p0_0/gf180mcu_fd_sc_mcu9t5v0__inv_1_3/I 0
C168 adc_dac6 vbp 0.04613f
C169 amx acp 0.15156f
C170 adc_sample xo_mode1 0
C171 adc_mux3 rc_trim3 0.04044f
C172 rc_trim2 adc_dac3 0.04044f
C173 mux_en xo_en 0.16308f
C174 smp bod_level2 0.1301f
C175 mux_en cmpa 0.05965f
C176 smp rc_trim4 0.04844f
C177 adc_dac6 adc_dac3 0.04144f
C178 acp adc_mux1 0
C179 ain1 adc_en 0.05682f
C180 cmpa aref 0.4376f
C181 adc_dac0 bod_level2 0.05368f
C182 rc_trim5 xo_mode1 0
C183 aref xo_en 0.30786f
C184 rv328_glue_0/rv328_glue_p0_0/gf180mcu_fd_sc_mcu9t5v0__inv_1_7/I rv328_glue_0/rv328_glue_p0_0/gf180mcu_fd_sc_mcu9t5v0__nand2_1_4/ZN 0
C185 rc_trim4 adc_dac0 0.04608f
C186 ac_en adc7 0.04908f
C187 ac_en rv328_glue_0/rv328_glue_p0_0/gf180mcu_fd_sc_mcu9t5v0__inv_1_8/ZN 0.13979f
C188 vbp rc_trim6 0.13938f
C189 rv328_glue_0/rv328_glue_p0_0/gf180mcu_fd_sc_mcu9t5v0__nand3_1_1/a_271_69# rv328_glue_0/rv328_glue_p0_0/gf180mcu_fd_sc_mcu9t5v0__inv_1_5/ZN 0
C190 ac_out en_buf 0.0578f
C191 ac_mux_en adc_dac4 0.04044f
C192 vbp adc_dac7 0.04613f
C193 vref ac_bg 2.02936f
C194 rv328_glue_0/rv328_glue_p0_0/gf180mcu_fd_sc_mcu9t5v0__inv_1_5/ZN rv328_glue_0/rv328_glue_p0_0/gf180mcu_fd_sc_mcu9t5v0__inv_1_6/ZN 0.04484f
C195 rc_trim6 adc_dac3 0.04044f
C196 avdd adc_dac5 0.99579f
C197 adc_dac3 adc_dac7 0.041f
C198 rc_trim5 rc_trim0 0.04072f
C199 adc_dac8 ac_out 0.04683f
C200 adc_mux2 xo_mode1 0.04179f
C201 ac_en rc_trim3 0.08344f
C202 rv328_glue_0/rv328_glue_p0_0/gf180mcu_fd_sc_mcu9t5v0__inv_1_7/I adc_sample 0.02726f
C203 bod_en bg_en 6.03395f
C204 rv328_glue_0/rv328_glue_p0_0/gf180mcu_fd_sc_mcu9t5v0__nand2_1_4/ZN rv328_glue_0/rv328_glue_p0_0/gf180mcu_fd_sc_mcu9t5v0__inv_1_4/I 0.00135f
C205 rv328_glue_0/rv328_glue_p0_0/gf180mcu_fd_sc_mcu9t5v0__nand2_1_3/a_245_69# avdd 0
C206 avdd adc2 0.4361f
C207 adc_cmp adc_mux0 0.04908f
C208 adc7 amx 8.93854f
C209 adc_dac9 adc_refs0 0.0452f
C210 adc_sample rv328_glue_0/rv328_glue_p0_0/gf180mcu_fd_sc_mcu9t5v0__nand2_1_7/ZN 0.02046f
C211 mux_en rv328_glue_0/rv328_glue_p0_0/gf180mcu_fd_sc_mcu9t5v0__nor2_1_1/ZN 0.02045f
C212 adc7 adc_mux1 0.04908f
C213 adc_en xo_mode1 0.13028f
C214 adc_mux0 adc1 0.04044f
C215 rc_trim0 adc_mux2 0.04044f
C216 adc6 avdd 0.4361f
C217 avdd rv328_glue_0/rv328_glue_p0_0/gf180mcu_fd_sc_mcu9t5v0__nand2_1_2/a_245_69# 0
C218 smp adc_mux3 0.09024f
C219 aref rv328_glue_0/rv328_glue_p0_0/gf180mcu_fd_sc_mcu9t5v0__nor2_1_1/ZN 0.00198f
C220 rv328_glue_0/rv328_glue_p0_0/gf180mcu_fd_sc_mcu9t5v0__nand3_1_1/a_271_69# avdd 0
C221 adc_en rc_trim0 0.08848f
C222 adc_sample rv328_glue_0/rv328_glue_p0_0/gf180mcu_fd_sc_mcu9t5v0__inv_1_4/I 0.03617f
C223 amx rc_trim3 0.05772f
C224 vbp mux_en 0.20959f
C225 adc_refs0 xo_en 0.10925f
C226 adc_refs0 cmpa 0.11709f
C227 rv328_glue_0/rv328_glue_p0_0/gf180mcu_fd_sc_mcu9t5v0__nor2_1_2/ZN rv328_glue_0/rv328_glue_p0_0/gf180mcu_fd_sc_mcu9t5v0__inv_1_8/ZN 0.27064f
C228 adc_dac9 rc_trim7 0.0452f
C229 en_avcc en_buf 43.93397f
C230 avdd rv328_glue_0/rv328_glue_p0_0/gf180mcu_fd_sc_mcu9t5v0__inv_1_6/ZN 0.54988f
C231 rc_trim3 adc_mux1 0.04044f
C232 adc_mux3 adc_dac0 0.04608f
C233 avdd rv328_glue_0/rv328_glue_p0_0/gf180mcu_fd_sc_mcu9t5v0__nand2_1_5/a_245_69# 0
C234 adc_dac2 bod_en 0.04044f
C235 vbp aref 19.3445f
C236 adc_cmp en_buf 0.0568f
C237 ac_mux_en rc_en 0.09352f
C238 avdd rc_trim1 0.54558f
C239 aref adc_dac3 0.2369f
C240 clk_lf clk_xa 0.04908f
C241 adc_dac4 rc_en 0.04804f
C242 adc_cmp adc_dac8 0.04548f
C243 rv328_glue_0/rv328_glue_p0_0/gf180mcu_fd_sc_mcu9t5v0__inv_1_7/I adc_en 0.02008f
C244 clk_rc xo_mode1 0.06027f
C245 cmpa rc_trim7 0.0452f
C246 adc_refs1 bg_en 1.67411f
C247 adc_dac9 bod_level1 0.0452f
C248 rc_trim7 xo_en 33.0876f
C249 adc_en rv328_glue_0/rv328_glue_p0_0/gf180mcu_fd_sc_mcu9t5v0__nand2_1_7/ZN 0.02054f
C250 vtemp ac_bg 0.05758f
C251 smp ac_en 0.16998f
C252 adc_sample bod_en 0.10846f
C253 clk_rc rc_trim0 0.01258f
C254 lv1 bg_en 0.06116f
C255 vtemp vref 9.72394f
C256 smp por_n 15.6646f
C257 ac_en adc_dac0 0.04608f
C258 adc_refs0 rv328_glue_0/rv328_glue_p0_0/gf180mcu_fd_sc_mcu9t5v0__nor2_1_1/ZN 0.0176f
C259 adc_en rv328_glue_0/rv328_glue_p0_0/gf180mcu_fd_sc_mcu9t5v0__inv_1_4/I 1.05239f
C260 cmpa bod_level1 0.1053f
C261 bod_level1 xo_en 0.10938f
C262 rv328_glue_0/rv328_glue_p0_0/gf180mcu_fd_sc_mcu9t5v0__inv_1_5/ZN en_buf 0.44527f
C263 rv328_glue_0/rv328_glue_p0_0/gf180mcu_fd_sc_mcu9t5v0__inv_1_7/I rv328_glue_0/rv328_glue_p0_0/gf180mcu_fd_sc_mcu9t5v0__nor2_1_0/a_234_573# 0.02957f
C264 aco xo_en 0.01896f
C265 cmpa aco 0.10859f
C266 rc_trim5 bod_en 0.0882f
C267 adc_dac9 bod_o 0
C268 ac_mux_en clk_lf 0.05771f
C269 avdd adc_mux0 1.34189f
C270 adc_dac6 ac_out 0.04683f
C271 adc_refs1 adc_dac2 0.04044f
C272 smp amx 0.12888f
C273 xo_mode1 xo_mode0 92.02551f
C274 ac_out rv328_glue_0/rv328_glue_p0_0/gf180mcu_fd_sc_mcu9t5v0__inv_1_8/I 0.01437f
C275 smp adc_mux1 0.09024f
C276 ain0 adc_mux0 0
C277 adc_refs1 rv328_glue_0/rv328_glue_p0_0/gf180mcu_fd_sc_mcu9t5v0__nand2_1_4/ZN 0.16738f
C278 rv328_glue_0/rv328_glue_p0_0/gf180mcu_fd_sc_mcu9t5v0__inv_1_3/I rv328_glue_0/rv328_glue_p0_0/gf180mcu_fd_sc_mcu9t5v0__inv_1_4/I 0.02438f
C279 vbp adc_refs0 0.16164f
C280 bod_level0 xo_mode1 0.04179f
C281 adc4 ac_bg 0.043f
C282 amx adc_dac0 0.04709f
C283 adc_refs0 adc_dac3 0.04044f
C284 rv328_glue_0/rv328_glue_p0_0/gf180mcu_fd_sc_mcu9t5v0__nand2_1_4/a_245_69# rv328_glue_0/rv328_glue_p0_0/gf180mcu_fd_sc_mcu9t5v0__nand2_1_4/ZN 0.0162f
C285 cmpa bod_o 0.10576f
C286 ok cmpa 0.04804f
C287 bod_en adc_mux2 0.04044f
C288 ok xo_en 0.10657f
C289 adc_dac1 rc_trim3 0.04044f
C290 adc_mux1 adc_dac0 0.04608f
C291 bod_level0 rc_trim0 0.04044f
C292 smp rv328_glue_0/rv328_glue_p0_0/gf180mcu_fd_sc_mcu9t5v0__nor2_1_2/ZN 0.11704f
C293 rv328_glue_0/rv328_glue_p0_0/gf180mcu_fd_sc_mcu9t5v0__nand2_1_4/ZN lv1 0
C294 rv328_glue_0/rv328_glue_p0_0/gf180mcu_fd_sc_mcu9t5v0__nand3_1_1/a_455_69# rv328_glue_0/rv328_glue_p0_0/gf180mcu_fd_sc_mcu9t5v0__inv_1_4/I 0.01168f
C295 vref bg_en 0.09487f
C296 vref adc4 0.05254f
C297 ac_out adc_dac7 0.04683f
C298 adc_en bod_en 0.18708f
C299 adc_refs1 adc_sample 5.68505f
C300 vbp rc_trim7 0.13938f
C301 acm vbp 4.46969f
C302 avdd en_buf 0.29019f
C303 ac_mux_en adc5 0.04044f
C304 bod_level1 rv328_glue_0/rv328_glue_p0_0/gf180mcu_fd_sc_mcu9t5v0__nor2_1_1/ZN 0.04606f
C305 adc_dac9 bod_level2 0.0528f
C306 aco rv328_glue_0/rv328_glue_p0_0/gf180mcu_fd_sc_mcu9t5v0__nor2_1_1/ZN 0.01761f
C307 rc_trim7 adc_dac3 0.04044f
C308 rc_trim4 adc_dac9 0.0452f
C309 adc_refs1 rc_trim5 0.0452f
C310 adc_dac2 ac_bg 0.04179f
C311 adc_dac8 avdd 0.98727f
C312 xo_mode0 rv328_glue_0/rv328_glue_p0_0/gf180mcu_fd_sc_mcu9t5v0__nand2_1_7/ZN 1.06373f
C313 mux_en adc0 0.05109f
C314 adc_sample lv1 0.08309f
C315 rv328_glue_0/rv328_glue_p0_0/gf180mcu_fd_sc_mcu9t5v0__nand3_1_0/a_271_69# en_buf 0
C316 adc_dac5 xo_mode1 0.04179f
C317 en_avcc rv328_glue_0/rv328_glue_p0_0/gf180mcu_fd_sc_mcu9t5v0__inv_1_8/I 0.01437f
C318 vbp bod_level1 0.15049f
C319 adc_cmp adc_dac6 0.04548f
C320 ac_mux_en acp 0.15269f
C321 adc_cmp rv328_glue_0/rv328_glue_p0_0/gf180mcu_fd_sc_mcu9t5v0__inv_1_8/I 0.01437f
C322 vbp aco 0.14546f
C323 cmpa bod_level2 5.63303f
C324 bod_level1 adc_dac3 0.04044f
C325 rc_trim4 cmpa 0.0452f
C326 rc_trim5 lv1 0.08739f
C327 xo_en bod_level2 0.12243f
C328 rc_trim4 xo_en 0.02144f
C329 aco adc_dac3 0.02128f
C330 adc_refs1 adc_mux2 0.04044f
C331 adc_dac5 rc_trim0 0.04044f
C332 mux_en ac_out 0.04436f
C333 clk_rc bod_en 0.1036f
C334 adc_sample ac_bg 0.05164f
C335 smp adc_dac1 0.04608f
C336 adc_refs1 adc_en 0.21996f
C337 ac_out aref 0.13622f
C338 adc_cmp adc_dac7 0.04548f
C339 ok vbp 1.15853f
C340 vbp bod_o 0.0515f
C341 adc_dac1 adc_dac0 40.6881f
C342 ac_bg rc_trim5 0.043f
C343 adc_sample vref 0.17647f
C344 vtemp adc4 0.00709f
C345 adc_refs1 rv328_glue_0/rv328_glue_p0_0/gf180mcu_fd_sc_mcu9t5v0__inv_1_3/I 0
C346 adc_en lv1 0.05982f
C347 ac_mux_en adc7 0.04908f
C348 adc_dac9 adc_mux3 0.0452f
C349 vref rc_trim5 0.15243f
C350 ain1 adc_mux0 0
C351 rv328_glue_0/rv328_glue_p0_0/gf180mcu_fd_sc_mcu9t5v0__inv_1_0/I aref 0.00187f
C352 bod_en xo_mode0 0.12879f
C353 rv328_glue_0/rv328_glue_p0_0/gf180mcu_fd_sc_mcu9t5v0__nor2_1_1/ZN bod_level2 0.02135f
C354 ac_bg adc_mux2 0.04319f
C355 bod_level0 bod_en 59.402f
C356 mux_en en_avcc 0.002f
C357 rv328_glue_0/rv328_glue_p0_0/gf180mcu_fd_sc_mcu9t5v0__nand3_1_1/a_455_69# adc_refs1 0
C358 rc_trim1 rc_trim0 38.0099f
C359 adc_mux3 xo_en 0.04044f
C360 cmpa adc_mux3 0.08564f
C361 adc_refs1 clk_rc 0.05383f
C362 ac_mux_en rc_trim3 0.08088f
C363 vref adc_mux2 0.05168f
C364 adc_cmp mux_en 0.05172f
C365 adc_en ac_bg 0.13554f
C366 rv328_glue_0/rv328_glue_p0_0/gf180mcu_fd_sc_mcu9t5v0__inv_1_7/I rv328_glue_0/rv328_glue_p0_0/gf180mcu_fd_sc_mcu9t5v0__inv_1_6/ZN 0
C367 vbp bod_level2 0.15049f
C368 en_avcc aref 0.52822f
C369 rc_trim4 vbp 0.13938f
C370 mux_en adc1 0.043f
C371 adc_dac4 rc_trim3 0.04044f
C372 adc_refs0 ac_out 0.02713f
C373 avdd rc_trim2 0.54558f
C374 adc_dac3 bod_level2 0.04804f
C375 ac_en adc_dac9 0.0452f
C376 adc_cmp aref 0.13749f
C377 adc3 ac_bg 0.043f
C378 rc_trim4 adc_dac3 0.04044f
C379 clk_rc lv1 0.10279f
C380 adc_dac6 avdd 0.98728f
C381 vref adc_en 0.16863f
C382 avdd rv328_glue_0/rv328_glue_p0_0/gf180mcu_fd_sc_mcu9t5v0__inv_1_8/I 0.48355f
C383 smp clk_xa 0.0536f
C384 adc_mux0 xo_mode1 0.04179f
C385 rv328_glue_0/rv328_glue_p0_0/gf180mcu_fd_sc_mcu9t5v0__nand3_1_1/a_271_69# rv328_glue_0/rv328_glue_p0_0/gf180mcu_fd_sc_mcu9t5v0__inv_1_4/I 0.00232f
C386 adc3 vref 0.05254f
C387 rv328_glue_0/rv328_glue_p0_0/gf180mcu_fd_sc_mcu9t5v0__inv_1_4/I rv328_glue_0/rv328_glue_p0_0/gf180mcu_fd_sc_mcu9t5v0__inv_1_6/ZN 0.23853f
C388 adc_dac5 bod_en 0.04044f
C389 rv328_glue_0/rv328_glue_p0_0/gf180mcu_fd_sc_mcu9t5v0__inv_1_3/I vref 0
C390 adc_mux0 rc_trim0 0.04044f
C391 adc_refs1 xo_mode0 0.08572f
C392 ac_en cmpa 0.15656f
C393 avdd rc_trim6 0.55268f
C394 ac_en xo_en 0.16009f
C395 avdd adc_dac7 0.98727f
C396 adc_refs1 bod_level0 0
C397 adc_dac9 amx 0.05845f
C398 mux_en rv328_glue_0/rv328_glue_p0_0/gf180mcu_fd_sc_mcu9t5v0__inv_1_5/ZN 0.19398f
C399 aco adc0 0.06028f
C400 clk_rc ac_bg 0.04804f
C401 adc_dac9 adc_mux1 0.0452f
C402 cmpa por_n 15.5071f
C403 lv1 xo_mode0 0.13535f
C404 rv328_glue_0/rv328_glue_p0_0/gf180mcu_fd_sc_mcu9t5v0__inv_1_5/ZN aref 0.00127f
C405 rv328_glue_0/rv328_glue_p0_0/gf180mcu_fd_sc_mcu9t5v0__nand2_1_4/ZN bg_en 0
C406 en_buf xo_mode1 0
C407 bod_level0 lv1 49.8368f
C408 ac_mux_en smp 0.13068f
C409 clk_rc vref 0.17287f
C410 adc_refs0 en_avcc 0.08534f
C411 rv328_glue_0/rv328_glue_p0_0/gf180mcu_fd_sc_mcu9t5v0__nor2_1_2/a_234_573# avdd 0.02768f
C412 ac_out bod_level1 0
C413 amx xo_en 0.05772f
C414 amx cmpa 0.11617f
C415 ac_out aco 72.33533f
C416 vbp adc_mux3 0.04646f
C417 adc_dac8 xo_mode1 0.04179f
C418 rc_en rc_trim3 0.04088f
C419 smp adc_dac4 0.04614f
C420 adc_cmp adc_refs0 0.05556f
C421 adc_mux1 xo_en 0.04044f
C422 cmpa adc_mux1 0.08564f
C423 ac_mux_en adc_dac0 0.04608f
C424 adc_dac3 adc_mux3 0.04044f
C425 vtemp adc_mux2 0.05581f
C426 adc_sample bg_en 4.61174f
C427 ac_bg xo_mode0 0.043f
C428 adc_dac4 adc_dac0 0.041f
C429 adc_dac8 rc_trim0 0.04044f
C430 adc_refs1 adc_dac5 0.04044f
C431 ac_en rv328_glue_0/rv328_glue_p0_0/gf180mcu_fd_sc_mcu9t5v0__nor2_1_1/ZN 1.93854f
C432 mux_en avdd 33.80637f
C433 bod_en rc_trim1 0.0882f
C434 bod_level0 ac_bg 0.043f
C435 cmpa rv328_glue_0/rv328_glue_p0_0/gf180mcu_fd_sc_mcu9t5v0__nor2_1_2/ZN 0.04215f
C436 vtemp adc_en 0.05254f
C437 ok ac_out 0.04436f
C438 mux_en ain0 0.3123f
C439 rv328_glue_0/rv328_glue_p0_0/gf180mcu_fd_sc_mcu9t5v0__nor2_1_2/ZN xo_en 0.168f
C440 aco rv328_glue_0/rv328_glue_p0_0/gf180mcu_fd_sc_mcu9t5v0__inv_1_0/I 1.09587f
C441 vref xo_mode0 0.19979f
C442 avdd aref 3.13393f
C443 rv328_glue_0/rv328_glue_p0_0/gf180mcu_fd_sc_mcu9t5v0__inv_1_7/I en_buf 0.01441f
C444 bod_level0 vref 0.05254f
C445 vtemp adc3 0.00883f
C446 ac_en vbp 0.78967f
C447 en_buf rv328_glue_0/rv328_glue_p0_0/gf180mcu_fd_sc_mcu9t5v0__nand2_1_7/ZN 0.02053f
C448 adc_en rv328_glue_0/rv328_glue_p0_0/gf180mcu_fd_sc_mcu9t5v0__nand3_1_0/a_455_69# 0.00394f
C449 rv328_glue_0/rv328_glue_p0_0/gf180mcu_fd_sc_mcu9t5v0__inv_1_5/ZN adc_refs0 0.81784f
C450 en_avcc bod_level1 0.10064f
C451 ac_en adc_dac3 0.04044f
C452 en_avcc aco 0.06649f
C453 adc4 adc_mux2 0.04044f
C454 vbp por_n 0.10155f
C455 rv328_glue_0/rv328_glue_p0_0/gf180mcu_fd_sc_mcu9t5v0__nand3_1_1/a_271_69# adc_refs1 0.00297f
C456 adc_dac9 adc_dac1 0.04533f
C457 adc_cmp bod_level1 0
C458 adc_en rv328_glue_0/rv328_glue_p0_0/gf180mcu_fd_sc_mcu9t5v0__nand2_1_1/a_245_69# 0
C459 rv328_glue_0/rv328_glue_p0_0/gf180mcu_fd_sc_mcu9t5v0__inv_1_3/I rv328_glue_0/rv328_glue_p0_0/gf180mcu_fd_sc_mcu9t5v0__nand3_1_0/a_455_69# 0.01168f
C460 adc_sample rv328_glue_0/rv328_glue_p0_0/gf180mcu_fd_sc_mcu9t5v0__nand2_1_4/ZN 0.03315f
C461 adc_cmp aco 72.26033f
C462 rv328_glue_0/rv328_glue_p0_0/gf180mcu_fd_sc_mcu9t5v0__inv_1_4/I en_buf 1.16128f
C463 smp rc_en 0.05605f
C464 aco adc1 0.05164f
C465 bod_en adc_mux0 0.04044f
C466 vbp amx 0.14341f
C467 adc_en adc4 0.04044f
C468 ac_bg adc_dac5 0.04179f
C469 adc_dac2 rc_trim5 0.04044f
C470 adc_en bg_en 0.10521f
C471 ac_out bod_level2 0
C472 rv328_glue_0/rv328_glue_p0_0/gf180mcu_fd_sc_mcu9t5v0__nor2_1_2/ZN rv328_glue_0/rv328_glue_p0_0/gf180mcu_fd_sc_mcu9t5v0__nor2_1_1/ZN 0.70612f
C473 vbp adc_mux1 0.04646f
C474 amx adc_dac3 0.04709f
C475 adc_refs1 rc_trim1 0.0452f
C476 adc3 adc4 12.1306f
C477 cmpa adc_dac1 0.15793f
C478 rc_en adc_dac0 0.05368f
C479 ac_bg adc2 0.043f
C480 adc_dac1 xo_en 0.04044f
C481 adc_dac3 adc_mux1 0.04044f
C482 ok adc_cmp 0.05164f
C483 adc6 ac_bg 0.043f
C484 adc_dac2 adc_mux2 0.04044f
C485 adc_refs0 avdd 1.48539f
C486 lv1 rc_trim1 0.08766f
C487 vref adc2 0.05254f
C488 rc_trim2 xo_mode1 0
C489 rv328_glue_0/rv328_glue_p0_0/gf180mcu_fd_sc_mcu9t5v0__inv_1_5/ZN aco 0.01911f
C490 adc_dac6 xo_mode1 0.04179f
C491 adc6 vref 0.05254f
C492 bod_en en_buf 0.04138f
C493 xo_mode1 rv328_glue_0/rv328_glue_p0_0/gf180mcu_fd_sc_mcu9t5v0__inv_1_8/I 0.38179f
C494 adc_dac2 adc_en 0.0913f
C495 adc_refs0 rv328_glue_0/rv328_glue_p0_0/gf180mcu_fd_sc_mcu9t5v0__nand3_1_0/a_271_69# 0.00292f
C496 adc_en rv328_glue_0/rv328_glue_p0_0/gf180mcu_fd_sc_mcu9t5v0__nand2_1_4/ZN 0.42905f
C497 adc0 adc_mux3 0.04853f
C498 smp clk_lf 0.18204f
C499 rc_trim2 rc_trim0 0.04216f
C500 rv328_glue_0/rv328_glue_p0_0/gf180mcu_fd_sc_mcu9t5v0__inv_1_1/I aref 0.00202f
C501 adc_dac8 bod_en 0.04044f
C502 adc_dac6 rc_trim0 0.04044f
C503 avdd rc_trim7 4.78803f
C504 acm avdd 4.28785f
C505 adc_refs1 adc_mux0 0.04044f
C506 adc_sample adc_mux2 0.04908f
C507 rc_trim6 xo_mode1 0
C508 acm ain0 10.17063f
C509 en_avcc bod_level2 0.24366f
C510 adc_dac9 clk_xa 0
C511 ac_bg rc_trim1 0.043f
C512 rv328_glue_0/rv328_glue_p0_0/gf180mcu_fd_sc_mcu9t5v0__inv_1_3/I rv328_glue_0/rv328_glue_p0_0/gf180mcu_fd_sc_mcu9t5v0__nand2_1_4/ZN 0
C513 xo_mode1 adc_dac7 0.04179f
C514 adc_cmp bod_level2 0
C515 ain1 mux_en 0.00716f
C516 ac_out adc_mux3 0.04179f
C517 rc_trim5 adc_mux2 0.04044f
C518 adc_sample adc_en 0.81491f
C519 vref rc_trim1 0.15243f
C520 rc_trim6 rc_trim0 0.04063f
C521 avdd bod_level1 1.22203f
C522 rc_trim0 adc_dac7 0.04044f
C523 rv328_glue_0/rv328_glue_p0_0/gf180mcu_fd_sc_mcu9t5v0__inv_1_7/I rv328_glue_0/rv328_glue_p0_0/gf180mcu_fd_sc_mcu9t5v0__inv_1_8/I 0
C524 avdd aco 33.75859f
C525 aco ain0 0.06028f
C526 vbp adc_dac1 0.04613f
C527 clk_xa xo_en 3.73515f
C528 cmpa clk_xa 45.7133f
C529 xo_mode0 bg_en 0.04056f
C530 rv328_glue_0/rv328_glue_p0_0/gf180mcu_fd_sc_mcu9t5v0__inv_1_8/I rv328_glue_0/rv328_glue_p0_0/gf180mcu_fd_sc_mcu9t5v0__nand2_1_7/ZN 1.66118f
C531 adc_en rc_trim5 0.08088f
C532 ac_en adc0 0.04853f
C533 rv328_glue_0/rv328_glue_p0_0/gf180mcu_fd_sc_mcu9t5v0__inv_1_3/I adc_sample 0.02866f
C534 adc_dac1 adc_dac3 0.0426f
C535 adc_refs1 en_buf 0.04087f
C536 vtemp adc2 0.01169f
C537 ac_mux_en adc_dac9 0.0452f
C538 adc_refs1 adc_dac8 0.04044f
C539 ac_bg adc_mux0 0.04344f
C540 avdd bod_o 27.8286f
C541 ok avdd 39.7284f
C542 mux_en xo_mode1 0.14249f
C543 adc_en adc_mux2 0.04122f
C544 lv1 en_buf 6.17452f
C545 ac_en ac_out 1.18411f
C546 adc_dac4 adc_dac9 0.04555f
C547 smp rv328_glue_0/rv328_glue_p0_0/gf180mcu_fd_sc_mcu9t5v0__inv_1_2/I 1.25082f
C548 amx adc0 0.05772f
C549 vref adc_mux0 0.05168f
C550 adc_sample clk_rc 7.36912f
C551 aref xo_mode1 0.30286f
C552 adc0 adc_mux1 0.04853f
C553 adc3 adc_mux2 0.04044f
C554 adc_dac2 xo_mode0 0.04044f
C555 mux_en rc_trim0 0.09183f
C556 bod_level0 adc_dac2 0.04044f
C557 ac_mux_en xo_en 0.1487f
C558 ac_mux_en cmpa 0.12618f
C559 adc_cmp adc_mux3 0.04908f
C560 adc_dac4 xo_en 0.04044f
C561 adc_mux3 adc1 0.04044f
C562 adc_dac4 cmpa 0.1274f
C563 amx ac_out 0.05907f
C564 adc3 adc_en 0.04044f
C565 aref rc_trim0 0.16664f
C566 ac_en rv328_glue_0/rv328_glue_p0_0/gf180mcu_fd_sc_mcu9t5v0__inv_1_0/I 0.45688f
C567 rv328_glue_0/rv328_glue_p0_0/gf180mcu_fd_sc_mcu9t5v0__inv_1_3/I adc_en 2.49803f
C568 ac_out adc_mux1 0.04179f
C569 rc_trim2 bod_en 0.0882f
C570 adc_dac6 bod_en 0.04044f
C571 bod_en rv328_glue_0/rv328_glue_p0_0/gf180mcu_fd_sc_mcu9t5v0__inv_1_8/I 0.01563f
C572 adc_dac8 ac_bg 0.04179f
C573 rv328_glue_0/rv328_glue_p0_0/gf180mcu_fd_sc_mcu9t5v0__inv_1_7/I mux_en 0.01998f
C574 rv328_glue_0/rv328_glue_p0_0/gf180mcu_fd_sc_mcu9t5v0__nand2_1_0/a_245_69# aco 0
C575 vref en_buf 0.04736f
C576 clk_rc adc_mux2 0.04548f
C577 vbp clk_xa 0.15642f
C578 adc_sample xo_mode0 0
C579 smp rv328_glue_0/rv328_glue_p0_0/gf180mcu_fd_sc_mcu9t5v0__inv_1_8/ZN 0.0477f
C580 avdd bod_level2 1.55633f
C581 rc_trim4 avdd 0.54736f
C582 mux_en rv328_glue_0/rv328_glue_p0_0/gf180mcu_fd_sc_mcu9t5v0__nand2_1_7/ZN 0.02063f
C583 rv328_glue_0/rv328_glue_p0_0/gf180mcu_fd_sc_mcu9t5v0__inv_1_1/I aco 0.0208f
C584 adc_sample bod_level0 0.05584f
C585 ac_en en_avcc 0.0923f
C586 rv328_glue_0/rv328_glue_p0_0/gf180mcu_fd_sc_mcu9t5v0__nand3_1_1/a_455_69# adc_en 0.00394f
C587 rv328_glue_0/rv328_glue_p0_0/gf180mcu_fd_sc_mcu9t5v0__inv_1_7/I aref 0.00202f
C588 ac_out rv328_glue_0/rv328_glue_p0_0/gf180mcu_fd_sc_mcu9t5v0__nor2_1_2/ZN 0.0345f
C589 acm ain1 3.72437f
C590 clk_rc adc_en 0.09455f
C591 aref rv328_glue_0/rv328_glue_p0_0/gf180mcu_fd_sc_mcu9t5v0__nand2_1_7/ZN 0.00198f
C592 ac_en adc_cmp 0.32647f
C593 rc_trim6 bod_en 0.0882f
C594 rc_trim5 xo_mode0 0
C595 adc_dac9 rc_en 0.0528f
C596 adc_dac2 adc_dac5 0.04144f
C597 bod_en adc_dac7 0.04044f
C598 bod_level0 rc_trim5 0.04044f
C599 ac_en adc1 0.04044f
C600 ac_mux_en rv328_glue_0/rv328_glue_p0_0/gf180mcu_fd_sc_mcu9t5v0__nor2_1_1/ZN 0.01762f
C601 smp rc_trim3 0.04844f
C602 adc_refs0 xo_mode1 0.08848f
C603 mux_en rv328_glue_0/rv328_glue_p0_0/gf180mcu_fd_sc_mcu9t5v0__inv_1_4/I 0.06055f
C604 bg_en rv328_glue_0/rv328_glue_p0_0/gf180mcu_fd_sc_mcu9t5v0__nand2_1_5/a_245_69# 0.0162f
C605 rv328_glue_0/rv328_glue_p0_0/gf180mcu_fd_sc_mcu9t5v0__nand2_1_3/a_245_69# rv328_glue_0/rv328_glue_p0_0/gf180mcu_fd_sc_mcu9t5v0__nand2_1_4/ZN 0
C606 aref rv328_glue_0/rv328_glue_p0_0/gf180mcu_fd_sc_mcu9t5v0__inv_1_4/I 0.00334f
C607 vtemp adc_mux0 0.05581f
C608 ain1 aco 0.06028f
C609 adc_mux2 xo_mode0 0.04044f
C610 rc_trim3 adc_dac0 0.04608f
C611 adc_refs0 rc_trim0 0.04804f
C612 adc_cmp amx 0.06636f
C613 cmpa rc_en 0.0528f
C614 ac_mux_en vbp 0.19525f
C615 adc_refs1 rc_trim2 0.0452f
C616 bod_level0 adc_mux2 0.04044f
C617 adc_refs1 adc_dac6 0.04044f
C618 rc_trim7 xo_mode1 0.00128f
C619 amx adc1 0.05772f
C620 ac_mux_en adc_dac3 0.04044f
C621 adc_sample adc_dac5 0.01258f
C622 adc_cmp adc_mux1 0.04908f
C623 adc_refs1 rv328_glue_0/rv328_glue_p0_0/gf180mcu_fd_sc_mcu9t5v0__inv_1_8/I 0.01437f
C624 adc_dac4 vbp 0.04613f
C625 adc_en xo_mode0 0.12132f
C626 adc_mux1 adc1 0.04044f
C627 ac_en rv328_glue_0/rv328_glue_p0_0/gf180mcu_fd_sc_mcu9t5v0__inv_1_5/ZN 0.02469f
C628 bod_level0 adc_en 0.04044f
C629 adc_dac4 adc_dac3 41.2562f
C630 rv328_glue_0/rv328_glue_p0_0/gf180mcu_fd_sc_mcu9t5v0__nor2_1_2/ZN en_avcc 0.04215f
C631 avdd adc_mux3 12.3918f
C632 rc_trim2 lv1 0.08758f
C633 rv328_glue_0/rv328_glue_p0_0/gf180mcu_fd_sc_mcu9t5v0__nand2_1_4/ZN rv328_glue_0/rv328_glue_p0_0/gf180mcu_fd_sc_mcu9t5v0__inv_1_6/ZN 0.52309f
C634 ac_out adc_dac1 0.04683f
C635 mux_en bod_en 0.08407f
C636 adc_dac5 rc_trim5 0.04044f
C637 rc_trim7 rc_trim0 0.04053f
C638 adc_dac9 clk_lf 0
C639 adc_cmp rv328_glue_0/rv328_glue_p0_0/gf180mcu_fd_sc_mcu9t5v0__nor2_1_2/ZN 0.03449f
C640 rv328_glue_0/rv328_glue_p0_0/gf180mcu_fd_sc_mcu9t5v0__inv_1_7/I adc_refs0 0.0199f
C641 lv1 rv328_glue_0/rv328_glue_p0_0/gf180mcu_fd_sc_mcu9t5v0__inv_1_8/I 0.01437f
C642 adc_refs1 rc_trim6 0.0452f
C643 adc_refs0 rv328_glue_0/rv328_glue_p0_0/gf180mcu_fd_sc_mcu9t5v0__nand2_1_7/ZN 0.02045f
C644 adc_refs1 adc_dac7 0.04044f
C645 adc_dac2 rc_trim1 0.04044f
C646 rv328_acsw_0/rv328_acsw_p0_0/gf180mcu_fd_sc_mcu9t5v0__inv_1_1/ZN avdd 2.41473f
C647 bod_level1 xo_mode1 0.08866f
C648 adc_sample rv328_glue_0/rv328_glue_p0_0/gf180mcu_fd_sc_mcu9t5v0__nand2_1_2/a_245_69# 0
C649 bod_en aref 0.13809f
C650 adc4 adc_mux0 0.04044f
C651 rv328_acsw_0/rv328_acsw_p0_0/gf180mcu_fd_sc_mcu9t5v0__inv_1_1/ZN ain0 0.381f
C652 adc_dac5 adc_mux2 0.04044f
C653 rc_trim6 lv1 0.08739f
C654 cmpa clk_lf 0.34652f
C655 rv328_glue_0/rv328_glue_p0_0/gf180mcu_fd_sc_mcu9t5v0__nand3_1_0/a_455_69# en_buf 0
C656 bod_level1 rc_trim0 0.04818f
C657 ac_bg rc_trim2 0.043f
C658 adc_refs0 rv328_glue_0/rv328_glue_p0_0/gf180mcu_fd_sc_mcu9t5v0__inv_1_4/I 0.67048f
C659 adc_dac6 ac_bg 0.04179f
C660 clk_rc xo_mode0 0.05771f
C661 smp adc_dac0 0.04608f
C662 adc2 adc_mux2 0.04044f
C663 bod_level0 clk_rc 0.04721f
C664 adc_en adc_dac5 0.0913f
C665 ac_en avdd 7.88783f
C666 vref rc_trim2 0.15243f
C667 ok xo_mode1 0.10712f
C668 ac_en ain0 0.04804f
C669 adc6 adc_mux2 0.04044f
C670 vbp rc_en 0.15202f
C671 avdd por_n 7.03277f
C672 adc_en adc2 0.04044f
C673 acm rv328_acsw_0/rv328_acsw_p0_0/gf180mcu_fd_sc_mcu9t5v0__inv_1_0/ZN 1.44567f
C674 rc_en adc_dac3 0.04804f
C675 adc_dac2 adc_mux0 0.04044f
C676 rc_trim6 ac_bg 0.043f
C677 rv328_glue_0/rv328_glue_p0_0/gf180mcu_fd_sc_mcu9t5v0__inv_1_7/I aco 0.01991f
C678 en_buf bg_en 0.04108f
C679 adc_refs1 mux_en 0.04079f
C680 rv328_glue_0/rv328_glue_p0_0/gf180mcu_fd_sc_mcu9t5v0__inv_1_7/I bod_level1 1.01193f
C681 ok rc_trim0 0.09885f
C682 ac_bg adc_dac7 0.04179f
C683 rc_trim5 rc_trim1 0.04088f
C684 adc_cmp adc_dac1 0.04548f
C685 adc6 adc_en 0.04044f
C686 bod_level1 rv328_glue_0/rv328_glue_p0_0/gf180mcu_fd_sc_mcu9t5v0__nand2_1_7/ZN 0.02051f
C687 adc3 adc2 12.0996f
C688 aco rv328_glue_0/rv328_glue_p0_0/gf180mcu_fd_sc_mcu9t5v0__nand2_1_7/ZN 0.02046f
C689 adc_en rv328_glue_0/rv328_glue_p0_0/gf180mcu_fd_sc_mcu9t5v0__nand2_1_2/a_245_69# 0
C690 amx avdd 2.04427f
C691 vref rc_trim6 0.15243f
C692 ac_out clk_xa 0.06045f
C693 adc_refs1 aref 0.14002f
C694 avdd adc_mux1 1.34541f
C695 amx ain0 0.10346f
C696 adc_refs0 bod_en 0.0603f
C697 rv328_glue_0/rv328_glue_p0_0/gf180mcu_fd_sc_mcu9t5v0__nand3_1_1/a_271_69# adc_en 0.00139f
C698 mux_en lv1 57.35518f
C699 bod_level0 xo_mode0 0.04044f
C700 ain0 adc_mux1 0
C701 adc_en rv328_glue_0/rv328_glue_p0_0/gf180mcu_fd_sc_mcu9t5v0__inv_1_6/ZN 1.0377f
C702 rc_trim1 adc_mux2 0.04044f
C703 aco rv328_glue_0/rv328_glue_p0_0/gf180mcu_fd_sc_mcu9t5v0__inv_1_4/I 0.01437f
C704 adc_sample adc_mux0 0.04908f
C705 aref lv1 0.13749f
C706 xo_mode1 bod_level2 0.10168f
C707 rc_trim4 xo_mode1 0
C708 ac_mux_en adc0 0.04853f
C709 cmpa rv328_glue_0/rv328_glue_p0_0/gf180mcu_fd_sc_mcu9t5v0__inv_1_2/I 0.04251f
C710 rv328_glue_0/rv328_glue_p0_0/gf180mcu_fd_sc_mcu9t5v0__nor2_1_2/ZN avdd 0.42162f
C711 adc_en rc_trim1 0.08088f
C712 rv328_glue_0/rv328_glue_p0_0/gf180mcu_fd_sc_mcu9t5v0__nand2_1_4/ZN en_buf 0.02932f
C713 rv328_glue_0/rv328_glue_p0_0/gf180mcu_fd_sc_mcu9t5v0__inv_1_3/I rv328_glue_0/rv328_glue_p0_0/gf180mcu_fd_sc_mcu9t5v0__inv_1_6/ZN 0
C714 vbp clk_lf 0.05509f
C715 rc_trim7 bod_en 0.0882f
C716 rc_trim0 bod_level2 0.05474f
C717 rc_trim5 adc_mux0 0.04044f
C718 mux_en ac_bg 0.10368f
C719 adc_dac8 adc_dac2 0.04069f
C720 rc_trim4 rc_trim0 0.04088f
C721 rv328_glue_0/rv328_glue_p0_0/gf180mcu_fd_sc_mcu9t5v0__nand2_1_0/a_245_69# ac_en 0
C722 ac_mux_en ac_out 4.19315f
C723 vref mux_en 0.22179f
C724 rv328_glue_0/rv328_glue_p0_0/gf180mcu_fd_sc_mcu9t5v0__inv_1_1/I ac_en 0.04821f
C725 adc_dac4 ac_out 0.04683f
C726 adc_dac5 xo_mode0 0.04044f
C727 adc_sample en_buf 0.06508f
C728 adc_mux0 adc_mux2 0.04216f
C729 ain1 rv328_acsw_0/rv328_acsw_p0_0/gf180mcu_fd_sc_mcu9t5v0__inv_1_1/ZN 0.02938f
C730 aco bod_en 0.06062f
C731 bod_level1 bod_en 50.35733f
C732 adc_refs1 adc_refs0 75.17964f
C733 bod_level0 adc_dac5 0.04044f
C734 adc_cmp clk_xa 0.05821f
C735 rv328_glue_0/rv328_glue_p0_0/gf180mcu_fd_sc_mcu9t5v0__inv_1_7/I bod_level2 1.98739f
C736 vref aref 60.3666f
C737 adc_dac9 rc_trim3 0.0452f
C738 cmpa rv328_glue_0/rv328_glue_p0_0/gf180mcu_fd_sc_mcu9t5v0__inv_1_8/ZN 0
C739 rv328_glue_0/rv328_glue_p0_0/gf180mcu_fd_sc_mcu9t5v0__nand2_1_7/ZN bod_level2 0.02048f
C740 xo_en rv328_glue_0/rv328_glue_p0_0/gf180mcu_fd_sc_mcu9t5v0__inv_1_8/ZN 0.00962f
C741 vbp adc5 0.04646f
C742 adc_sample adc_dac8 0.03039f
C743 adc_en adc_mux0 46.2703f
C744 clk_rc rc_trim1 0.01053f
C745 adc_refs0 lv1 0.05973f
C746 ac_en ain1 0.04853f
C747 avdd adc_dac1 1.00584f
C748 bod_o bod_en 5.48442f
C749 adc_mux3 xo_mode1 0.04179f
C750 adc3 adc_mux0 0.04044f
C751 adc_dac8 rc_trim5 0.04044f
C752 ok bod_en 0.16154f
C753 adc_refs1 rc_trim7 0.0452f
C754 cmpa rc_trim3 0.0452f
C755 vbp acp 0.1944f
C756 rc_trim3 xo_en 0.01711f
C757 ac_mux_en en_avcc 0.08248f
C758 xo_en rv328_glue_0/rv328_glue_p0_0/gf180mcu_fd_sc_mcu9t5v0__nand2_1_6/a_245_69# 0
C759 rv328_glue_0/rv328_glue_p0_0/gf180mcu_fd_sc_mcu9t5v0__inv_1_8/I bg_en 0.01437f
C760 adc_mux3 rc_trim0 0.04044f
C761 rc_trim7 lv1 0.08739f
C762 adc_dac8 adc_mux2 0.04044f
C763 adc_refs0 ac_bg 0.05109f
C764 ac_mux_en adc_cmp 0.09986f
C765 adc_en en_buf 0.07037f
C766 rc_trim1 xo_mode0 0
C767 ain1 amx 11.20931f
C768 adc_refs1 bod_level1 0.04224f
C769 ac_mux_en adc1 0.04044f
C770 adc_refs1 aco 0.03795f
C771 adc_cmp adc_dac4 0.04548f
C772 rv328_glue_0/rv328_glue_p0_0/gf180mcu_fd_sc_mcu9t5v0__nor2_1_1/ZN rv328_glue_0/rv328_glue_p0_0/gf180mcu_fd_sc_mcu9t5v0__inv_1_8/ZN 1.06949f
C773 bod_level0 rc_trim1 0.04044f
C774 clk_rc adc_mux0 0.04548f
C775 vref adc_refs0 0.16861f
C776 adc_dac8 adc_en 0.0913f
C777 ac_en xo_mode1 0.14161f
C778 vtemp mux_en 0.06085f
C779 rv328_glue_0/rv328_glue_p0_0/gf180mcu_fd_sc_mcu9t5v0__inv_1_3/I en_buf 0.00435f
C780 smp adc_dac9 0.25182f
C781 adc_dac2 rc_trim2 0.04044f
C782 aco lv1 0.05949f
C783 bod_level1 lv1 0.06049f
C784 bod_en bod_level2 0.08808f
C785 rc_trim4 bod_en 0.0882f
C786 ac_bg rc_trim7 0.043f
C787 adc_dac2 adc_dac6 0.041f
C788 adc7 vbp 0.05509f
C789 acm ac_bg 0.11287f
C790 ac_en rc_trim0 0.09104f
C791 adc_refs1 ok 0.0452f
C792 adc_dac9 adc_dac0 0.04524f
C793 ac_mux_en rv328_glue_0/rv328_glue_p0_0/gf180mcu_fd_sc_mcu9t5v0__inv_1_5/ZN 0
C794 xtal2 xtal1 2.94074f
C795 vref rc_trim7 0.15243f
C796 acm vref 0.32402f
C797 avdd clk_xa 2.00315f
C798 amx xo_mode1 0.05907f
C799 smp xo_en 6.54965f
C800 smp cmpa 70.72961f
C801 adc_mux0 xo_mode0 0.04044f
C802 rv328_glue_0/rv328_glue_p0_0/gf180mcu_fd_sc_mcu9t5v0__nand2_1_3/a_245_69# rv328_glue_0/rv328_glue_p0_0/gf180mcu_fd_sc_mcu9t5v0__inv_1_6/ZN 0
C803 bod_o lv1 0.01258f
C804 ok lv1 43.6412f
C805 adc_dac2 rc_trim6 0.04044f
C806 ac_bg bod_level1 0.043f
C807 adc_mux1 xo_mode1 0.04179f
C808 ac_bg aco 0.043f
C809 bod_level0 adc_mux0 0.04044f
C810 vbp rc_trim3 0.13938f
C811 adc_dac2 adc_dac7 0.0408f
C812 adc_dac5 rc_trim1 0.04044f
C813 rv328_acsw_0/rv328_acsw_p0_0/gf180mcu_fd_sc_mcu9t5v0__inv_1_1/ZN rv328_acsw_0/rv328_acsw_p0_0/gf180mcu_fd_sc_mcu9t5v0__inv_1_0/ZN 0.34499f
C814 adc_dac8 clk_rc 0
C815 cmpa adc_dac0 11.4831f
C816 rv328_glue_0/rv328_glue_p0_0/gf180mcu_fd_sc_mcu9t5v0__inv_1_7/I ac_en 0.02791f
C817 mux_en adc4 0.043f
C818 adc_dac3 rc_trim3 0.04044f
C819 xo_en adc_dac0 0.04608f
C820 adc_sample adc_dac6 0.01564f
C821 amx rc_trim0 0.05772f
C822 adc_sample rv328_glue_0/rv328_glue_p0_0/gf180mcu_fd_sc_mcu9t5v0__inv_1_8/I 0.01437f
C823 mux_en bg_en 0.04076f
C824 ac_en rv328_glue_0/rv328_glue_p0_0/gf180mcu_fd_sc_mcu9t5v0__nand2_1_7/ZN 0.02056f
C825 vref bod_level1 0.15747f
C826 vref aco 0.15243f
C827 rc_trim0 adc_mux1 0.04044f
C828 rc_trim2 rc_trim5 0.04122f
C829 rv328_glue_0/rv328_glue_p0_0/gf180mcu_fd_sc_mcu9t5v0__nor2_1_2/ZN xo_mode1 0
C830 adc_dac6 rc_trim5 0.04044f
C831 aref bg_en 0.27432f
C832 ac_bg bod_o 0.04804f
C833 adc_refs1 bod_level2 0.04154f
C834 adc_refs1 rc_trim4 0.0452f
C835 en_buf xo_mode0 0
C836 ac_en rv328_glue_0/rv328_glue_p0_0/gf180mcu_fd_sc_mcu9t5v0__inv_1_4/I 0.01955f
C837 ac_mux_en avdd 11.97357f
C838 adc_sample adc_dac7 0.02065f
C839 bod_en adc_mux3 0.04608f
C840 ac_mux_en ain0 0.2521f
C841 rc_trim2 adc_mux2 0.04044f
C842 smp rv328_glue_0/rv328_glue_p0_0/gf180mcu_fd_sc_mcu9t5v0__nor2_1_1/ZN 0.0294f
C843 adc_dac4 avdd 0.99714f
C844 vref bod_o 0.05758f
C845 ok vref 0.10017f
C846 adc_dac8 xo_mode0 0.04044f
C847 adc_dac5 adc_mux0 0.04044f
C848 lv1 bod_level2 26.7911f
C849 rc_trim6 rc_trim5 37.4876f
C850 adc_dac6 adc_mux2 0.04044f
C851 rc_trim4 lv1 0.08745f
C852 bod_level0 adc_dac8 0.04044f
C853 rc_trim5 adc_dac7 0.04044f
C854 mux_en rv328_glue_0/rv328_glue_p0_0/gf180mcu_fd_sc_mcu9t5v0__nand2_1_4/ZN 1.17096f
C855 adc_en rc_trim2 0.08088f
C856 amx rv328_acsw_0/rv328_acsw_p0_0/gf180mcu_fd_sc_mcu9t5v0__inv_1_0/ZN 0.75619f
C857 adc2 adc_mux0 0.04044f
C858 rv328_glue_0/rv328_glue_p0_0/gf180mcu_fd_sc_mcu9t5v0__inv_1_7/I rv328_glue_0/rv328_glue_p0_0/gf180mcu_fd_sc_mcu9t5v0__nor2_1_2/ZN 0.24569f
C859 smp vbp 0.22206f
C860 adc_dac6 adc_en 0.0913f
C861 adc_dac2 aref 0.2369f
C862 adc_en rv328_glue_0/rv328_glue_p0_0/gf180mcu_fd_sc_mcu9t5v0__inv_1_8/I 0.05953f
C863 vtemp acm 0.10906f
C864 adc6 adc_mux0 0.04044f
C865 rv328_glue_0/rv328_glue_p0_0/gf180mcu_fd_sc_mcu9t5v0__nand2_1_4/ZN aref 0.00187f
C866 rv328_glue_0/rv328_glue_p0_0/gf180mcu_fd_sc_mcu9t5v0__nor2_1_2/ZN rv328_glue_0/rv328_glue_p0_0/gf180mcu_fd_sc_mcu9t5v0__nand2_1_7/ZN 0
C867 rc_trim6 adc_mux2 0.04044f
C868 smp adc_dac3 0.04608f
C869 adc_mux2 adc_dac7 0.04044f
C870 ac_out rv328_glue_0/rv328_glue_p0_0/gf180mcu_fd_sc_mcu9t5v0__inv_1_2/I 0.019f
C871 adc_dac1 xo_mode1 0.04179f
C872 ac_bg bod_level2 0.04804f
C873 ac_en bod_en 0.36891f
C874 vbp adc_dac0 0.04613f
C875 rc_trim4 ac_bg 0.043f
C876 adc_sample mux_en 0.05182f
C877 adc_refs0 bg_en 0.10532f
C878 adc_en rc_trim6 0.08088f
C879 adc_dac3 adc_dac0 0.04144f
C880 adc_en adc_dac7 0.0913f
C881 adc_refs1 adc_mux3 0.04608f
C882 vref bod_level2 0.15747f
C883 adc_dac1 rc_trim0 0.04044f
C884 por_n bod_en 0.05164f
C885 rc_trim4 vref 0.15243f
C886 adc_sample aref 0.13799f
C887 adc_dac8 adc_dac5 0.04144f
C888 mux_en rc_trim5 0.08351f
C889 rv328_glue_0/rv328_glue_p0_0/gf180mcu_fd_sc_mcu9t5v0__inv_1_0/I rv328_glue_0/rv328_glue_p0_0/gf180mcu_fd_sc_mcu9t5v0__inv_1_2/I 0
C890 adc_mux0 rc_trim1 0.04044f
C891 avdd rc_en 0.65963f
C892 amx bod_en 0.05772f
C893 bod_en adc_mux1 0.04044f
C894 rc_trim5 aref 0.13622f
C895 mux_en adc_mux2 0.11279f
C896 adc_dac2 adc_refs0 0.04044f
C897 en_avcc rv328_glue_0/rv328_glue_p0_0/gf180mcu_fd_sc_mcu9t5v0__inv_1_2/I 0
C898 adc_refs0 rv328_glue_0/rv328_glue_p0_0/gf180mcu_fd_sc_mcu9t5v0__nand2_1_4/ZN 0.02514f
C899 rv328_glue_0/rv328_glue_p0_0/gf180mcu_fd_sc_mcu9t5v0__inv_1_6/ZN en_buf 0.00586f
C900 adc_cmp rv328_glue_0/rv328_glue_p0_0/gf180mcu_fd_sc_mcu9t5v0__inv_1_2/I 0.03487f
C901 rv328_glue_0/rv328_glue_p0_0/gf180mcu_fd_sc_mcu9t5v0__nor2_1_2/ZN bod_en 1.25559f
C902 clk_rc adc_dac7 0
C903 adc_refs1 ac_en 0.32038f
C904 adc_en mux_en 0.18863f
C905 adc4 aco 0.05164f
C906 aco bg_en 0.01523f
C907 bod_level1 bg_en 0.19274f
C908 rc_trim2 xo_mode0 0
C909 ac_bg adc_mux3 0.04309f
C910 ac_en rv328_glue_0/rv328_glue_p0_0/gf180mcu_fd_sc_mcu9t5v0__nand2_1_4/a_245_69# 0
C911 adc3 mux_en 0.043f
C912 xo_mode1 clk_xa 0.06027f
C913 adc_dac6 xo_mode0 0.04044f
C914 xo_mode0 rv328_glue_0/rv328_glue_p0_0/gf180mcu_fd_sc_mcu9t5v0__inv_1_8/I 0.00107f
C915 bod_level0 rc_trim2 0.04044f
C916 adc_dac2 rc_trim7 0.04044f
C917 adc_en aref 0.44209f
C918 ac_mux_en ain1 0.84382f
C919 ac_en lv1 0.0898f
C920 rv328_glue_0/rv328_glue_p0_0/gf180mcu_fd_sc_mcu9t5v0__inv_1_3/I mux_en 0
C921 bod_level0 adc_dac6 0.04044f
C922 adc_sample adc_refs0 0.17067f
C923 vref adc_mux3 0.05168f
C924 adc_dac8 rc_trim1 0.04044f
C925 avdd clk_lf 1.42308f
C926 rv328_acsw_0/rv328_acsw_p0_0/gf180mcu_fd_sc_mcu9t5v0__inv_1_1/ZN ac_bg 0.88612f
C927 adc_refs1 amx 0.05772f
C928 ok bg_en 11.8445f
C929 por_n lv1 0.04908f
C930 rv328_glue_0/rv328_glue_p0_0/gf180mcu_fd_sc_mcu9t5v0__inv_1_3/I aref 0.00202f
C931 en_avcc rv328_glue_0/rv328_glue_p0_0/gf180mcu_fd_sc_mcu9t5v0__inv_1_8/ZN 0
C932 adc_refs1 adc_mux1 0.04044f
C933 adc_refs0 rc_trim5 0.04044f
C934 rc_trim6 xo_mode0 0.00128f
C935 adc_dac9 xo_en 0.0452f
C936 adc_dac9 cmpa 15.2019f
C937 vref rv328_acsw_0/rv328_acsw_p0_0/gf180mcu_fd_sc_mcu9t5v0__inv_1_1/ZN 0.30508f
C938 xo_mode0 adc_dac7 0.04044f
C939 adc_dac2 bod_level1 0.04044f
C940 adc_dac2 aco 0.02842f
C941 bod_level0 rc_trim6 0.04044f
C942 rv328_glue_0/rv328_glue_p0_0/gf180mcu_fd_sc_mcu9t5v0__inv_1_5/ZN rv328_glue_0/rv328_glue_p0_0/gf180mcu_fd_sc_mcu9t5v0__inv_1_2/I 0
C943 bod_level0 adc_dac7 0.04044f
C944 rv328_glue_0/rv328_glue_p0_0/gf180mcu_fd_sc_mcu9t5v0__nand2_1_4/ZN bod_level1 0
C945 clk_rc mux_en 0.09711f
C946 rv328_glue_0/rv328_glue_p0_0/gf180mcu_fd_sc_mcu9t5v0__nand2_1_4/ZN aco 0.02573f
C947 ac_en ac_bg 47.8053f
C948 adc_refs1 rv328_glue_0/rv328_glue_p0_0/gf180mcu_fd_sc_mcu9t5v0__nor2_1_2/ZN 0.03978f
C949 adc_refs0 adc_mux2 0.07524f
C950 adc_dac1 bod_en 0.04044f
C951 ac_mux_en xo_mode1 0.13028f
C952 rc_trim2 adc_dac5 0.04044f
C953 adc5 avdd 0.4361f
C954 ac_bg por_n 0.043f
C955 clk_rc aref 0.17077f
C956 cmpa xo_en 0.06547f
C957 adc_dac6 adc_dac5 41.635f
C958 rc_trim7 rc_trim5 0.04216f
C959 ac_en vref 0.17195f
C960 adc_dac4 xo_mode1 0.04179f
C961 adc_dac8 adc_mux0 0.04044f
C962 smp ac_out 0.11845f
C963 rv328_glue_0/rv328_glue_p0_0/gf180mcu_fd_sc_mcu9t5v0__nor2_1_2/ZN lv1 0.04318f
C964 adc_en adc_refs0 51.30268f
C965 ac_mux_en rc_trim0 0.08848f
C966 adc_sample bod_level1 0.06417f
C967 adc_sample aco 0.14279f
C968 vref por_n 0.11371f
C969 amx ac_bg 0.05868f
C970 bg_en bod_level2 0.04266f
C971 adc_dac4 rc_trim0 0.04044f
C972 ac_out adc_dac0 0.05247f
C973 ac_bg adc_mux1 0.04328f
C974 avdd acp 2.55254f
C975 rc_trim7 adc_mux2 0.04044f
C976 rc_trim6 adc_dac5 0.04044f
C977 acm adc_mux2 0
C978 mux_en xo_mode0 0.13423f
C979 bod_level1 rc_trim5 0.04044f
C980 ain0 acp 2.54803f
C981 rv328_glue_0/rv328_glue_p0_0/gf180mcu_fd_sc_mcu9t5v0__inv_1_3/I adc_refs0 0.05081f
C982 avdd rv328_glue_0/rv328_glue_p0_0/gf180mcu_fd_sc_mcu9t5v0__inv_1_2/I 0.83707f
C983 adc_dac5 adc_dac7 0.0426f
C984 bod_level0 mux_en 0.0406f
C985 vref amx 10.13639f
C986 smp rv328_glue_0/rv328_glue_p0_0/gf180mcu_fd_sc_mcu9t5v0__inv_1_0/I 0
C987 aref xo_mode0 0.27245f
C988 vref adc_mux1 0.05168f
C989 vtemp adc_mux3 0.05581f
C990 rv328_glue_0/rv328_glue_p0_0/gf180mcu_fd_sc_mcu9t5v0__inv_1_7/I ac_mux_en 0.0236f
C991 adc_sample bod_o 16.0551f
C992 adc_en rc_trim7 0.08088f
C993 ok adc_sample 0.0584f
C994 acm adc_en 0
C995 ac_mux_en rv328_glue_0/rv328_glue_p0_0/gf180mcu_fd_sc_mcu9t5v0__nand2_1_7/ZN 0.02047f
C996 adc_dac9 vbp 0.0575f
C997 bod_level1 adc_mux2 0.04044f
C998 adc_refs1 adc_dac1 0.04044f
C999 cmpa rv328_glue_0/rv328_glue_p0_0/gf180mcu_fd_sc_mcu9t5v0__nor2_1_1/ZN 0.02041f
C1000 xo_en rv328_glue_0/rv328_glue_p0_0/gf180mcu_fd_sc_mcu9t5v0__nor2_1_1/ZN 0.00113f
C1001 aco adc_mux2 0.04044f
C1002 adc_dac9 adc_dac3 0.04544f
C1003 adc_dac2 bod_level2 0.04804f
C1004 rc_trim2 rc_trim1 37.9054f
C1005 clk_rc adc_refs0 0.04908f
C1006 ok rc_trim5 0.08961f
C1007 rc_trim4 adc_dac2 0.04044f
C1008 smp en_avcc 0.19432f
C1009 adc_dac6 rc_trim1 0.04044f
C1010 ac_mux_en rv328_acsw_0/rv328_acsw_p0_0/gf180mcu_fd_sc_mcu9t5v0__inv_1_0/ZN 1.85332f
C1011 rv328_glue_0/rv328_glue_p0_0/gf180mcu_fd_sc_mcu9t5v0__nand2_1_4/ZN bod_level2 0
C1012 adc_en bod_level1 0.08175f
C1013 bod_en clk_xa 0.10525f
C1014 smp adc_cmp 0.10853f
C1015 adc_en aco 0.10623f
C1016 ac_mux_en rv328_glue_0/rv328_glue_p0_0/gf180mcu_fd_sc_mcu9t5v0__inv_1_4/I 0
C1017 adc7 avdd 0.56564f
C1018 avdd rv328_glue_0/rv328_glue_p0_0/gf180mcu_fd_sc_mcu9t5v0__inv_1_8/ZN 0.50186f
C1019 vbp cmpa 0.20799f
C1020 vbp xo_en 0.20032f
C1021 bod_o adc_mux2 0.04548f
C1022 adc_dac3 xo_en 0.04044f
C1023 adc3 aco 0.05164f
C1024 cmpa adc_dac3 0.13281f
C1025 vtemp ac_en 0.05254f
C1026 adc4 adc_mux3 0.04044f
C1027 adc_cmp adc_dac0 1.17589f
C1028 rc_trim6 rc_trim1 0.04072f
C1029 rc_en rc_trim0 35.6942f
C1030 rv328_glue_0/rv328_glue_p0_0/gf180mcu_fd_sc_mcu9t5v0__inv_1_3/I aco 0.02082f
C1031 rv328_glue_0/rv328_glue_p0_0/gf180mcu_fd_sc_mcu9t5v0__nand2_1_3/a_245_69# mux_en 0.0162f
C1032 adc_dac5 aref 0.2369f
C1033 mux_en adc2 0.043f
C1034 rc_trim1 adc_dac7 0.04044f
C1035 adc_sample bod_level2 0.04891f
C1036 adc_en bod_o 0.04548f
C1037 avdd rc_trim3 0.54574f
C1038 ok adc_en 0.04044f
C1039 adc6 mux_en 0.043f
C1040 adc_refs0 xo_mode0 0.08095f
C1041 ac_bg adc_dac1 0.04179f
C1042 bod_level0 adc_refs0 0
C1043 rc_trim2 adc_mux0 0.04044f
C1044 avdd rv328_glue_0/rv328_glue_p0_0/gf180mcu_fd_sc_mcu9t5v0__nand2_1_6/a_245_69# 0
C1045 rc_trim5 bod_level2 0.04695f
C1046 adc_dac6 adc_mux0 0.04044f
C1047 rc_trim4 rc_trim5 37.5921f
C1048 vtemp amx 0.36475f
C1049 ac_mux_en bod_en 0.0986f
C1050 rv328_glue_0/rv328_glue_p0_0/gf180mcu_fd_sc_mcu9t5v0__inv_1_1/I rv328_glue_0/rv328_glue_p0_0/gf180mcu_fd_sc_mcu9t5v0__inv_1_2/I 0.03746f
C1051 clk_rc bod_level1 0.04908f
C1052 smp rv328_glue_0/rv328_glue_p0_0/gf180mcu_fd_sc_mcu9t5v0__inv_1_5/ZN 0.10124f
C1053 clk_rc aco 0.11489f
C1054 vtemp adc_mux1 0.05581f
C1055 mux_en rv328_glue_0/rv328_glue_p0_0/gf180mcu_fd_sc_mcu9t5v0__inv_1_6/ZN 1.29474f
C1056 adc_refs1 clk_xa 0.06225f
C1057 adc_dac4 bod_en 0.04044f
C1058 adc_dac2 adc_mux3 0.04044f
C1059 ac_en adc4 0.04044f
C1060 rc_trim7 xo_mode0 0.00283f
C1061 ac_en bg_en 0.13962f
C1062 adc_mux2 bod_level2 0.04548f
C1063 rc_trim6 adc_mux0 0.04044f
C1064 bod_level0 rc_trim7 0.04044f
C1065 rc_trim4 adc_mux2 0.04044f
C1066 adc_mux0 adc_dac7 0.04044f
C1067 mux_en rc_trim1 0.08388f
C1068 ain1 acp 0.14652f
C1069 clk_rc bod_o 8.38958f
C1070 ok clk_rc 0.10748f
C1071 lv1 clk_xa 0.10443f
C1072 en_buf rv328_glue_0/rv328_glue_p0_0/gf180mcu_fd_sc_mcu9t5v0__inv_1_8/I 0.01437f
C1073 adc_en bod_level2 0.09494f
C1074 rc_trim4 adc_en 0.08088f
C1075 aref rc_trim1 0.13622f
C1076 adc_refs0 adc_dac5 0.04044f
C1077 vbp adc_dac3 0.04613f
C1078 adc_dac8 rc_trim2 0.04044f
C1079 bod_level1 xo_mode0 0.08106f
C1080 amx adc4 0.05772f
C1081 adc_sample adc_mux3 0.04908f
C1082 bod_level0 bod_level1 16.677f
C1083 adc_dac8 adc_dac6 0.0426f
C1084 adc4 adc_mux1 0.04044f
C1085 bod_level0 aco 0.04044f
C1086 smp avdd 4.26122f
C1087 ac_en adc_dac2 0.04044f
C1088 adc_refs1 ac_mux_en 0.08233f
C1089 ac_en rv328_glue_0/rv328_glue_p0_0/gf180mcu_fd_sc_mcu9t5v0__nand2_1_4/ZN 0.92881f
C1090 rc_trim5 adc_mux3 0.04044f
C1091 avdd adc_dac0 13.4208f
C1092 ac_bg clk_xa 0.043f
C1093 adc_dac5 rc_trim7 0.04044f
C1094 adc_refs1 adc_dac4 0.04044f
C1095 ac_mux_en rv328_glue_0/rv328_glue_p0_0/gf180mcu_fd_sc_mcu9t5v0__nand2_1_4/a_245_69# 0
C1096 ok xo_mode0 0.09816f
C1097 rv328_glue_0/rv328_glue_p0_0/gf180mcu_fd_sc_mcu9t5v0__nor2_1_2/ZN bg_en 1.41365f
C1098 mux_en adc_mux0 10.5773f
C1099 adc_dac8 rc_trim6 0.04044f
C1100 bod_en rc_en 0.09587f
C1101 adc_dac8 adc_dac7 42.0138f
C1102 ac_mux_en lv1 0.06395f
C1103 rv328_glue_0/rv328_glue_p0_0/gf180mcu_fd_sc_mcu9t5v0__nand3_1_1/a_271_69# adc_refs0 0.00292f
C1104 ok bod_level0 0.09638f
C1105 vref clk_xa 0.16948f
C1106 adc_dac9 ac_out 0.05159f
C1107 bod_level0 bod_o 1.03143f
C1108 clk_rc bod_level2 0.05558f
C1109 adc_dac2 amx 0.04709f
C1110 adc_refs0 rv328_glue_0/rv328_glue_p0_0/gf180mcu_fd_sc_mcu9t5v0__inv_1_6/ZN 0.00914f
C1111 adc_mux3 adc_mux2 56.3491f
C1112 ac_en adc_sample 0.14949f
C1113 adc_dac2 adc_mux1 0.04044f
C1114 adc_dac5 bod_level1 0.04044f
C1115 aco adc_dac5 0.01416f
C1116 adc_en adc_mux3 0.04088f
C1117 adc_refs0 rc_trim1 0.04044f
C1118 adc_sample por_n 0
C1119 ac_out xo_en 0.01897f
C1120 ac_out cmpa 0.12312f
C1121 ac_en rc_trim5 0.08344f
C1122 ac_mux_en ac_bg 9.75304f
C1123 aco adc2 0.05164f
C1124 mux_en en_buf 0.35672f
C1125 adc3 adc_mux3 0.04044f
C1126 rv328_glue_0/rv328_glue_p0_0/gf180mcu_fd_sc_mcu9t5v0__nor2_1_2/ZN rv328_glue_0/rv328_glue_p0_0/gf180mcu_fd_sc_mcu9t5v0__nand2_1_4/ZN 0
C1127 adc6 aco 0.05164f
C1128 adc_dac4 ac_bg 0.04179f
C1129 adc_sample amx 0.06636f
C1130 xo_mode1 rv328_glue_0/rv328_glue_p0_0/gf180mcu_fd_sc_mcu9t5v0__inv_1_8/ZN 0.01342f
C1131 xo_mode0 bod_level2 0.09413f
C1132 aref en_buf 0.25067f
C1133 rc_trim4 xo_mode0 0
C1134 adc_sample adc_mux1 0.04908f
C1135 ac_mux_en vref 0.84347f
C1136 bod_o adc_dac5 0
C1137 ac_en adc_mux2 0.04072f
C1138 bod_level0 bod_level2 0.04908f
C1139 rc_trim7 rc_trim1 0.04063f
C1140 adc_refs1 rc_en 0.0528f
C1141 bod_level0 rc_trim4 0.04044f
C1142 cmpa rv328_glue_0/rv328_glue_p0_0/gf180mcu_fd_sc_mcu9t5v0__inv_1_0/I 0.17512f
C1143 amx rc_trim5 0.05772f
C1144 rv328_glue_0/rv328_glue_p0_0/gf180mcu_fd_sc_mcu9t5v0__inv_1_1/I smp 0.02188f
C1145 adc_dac8 aref 0.2369f
C1146 rv328_acsw_0/rv328_acsw_p0_0/gf180mcu_fd_sc_mcu9t5v0__inv_1_0/ZN acp 0.10702f
C1147 bod_level1 rv328_glue_0/rv328_glue_p0_0/gf180mcu_fd_sc_mcu9t5v0__inv_1_6/ZN 0
C1148 rc_trim5 adc_mux1 0.04044f
C1149 por_n adc_mux2 0.04044f
C1150 adc_cmp adc_dac9 0.05024f
C1151 rc_trim3 xo_mode1 0
C1152 adc_sample rv328_glue_0/rv328_glue_p0_0/gf180mcu_fd_sc_mcu9t5v0__nor2_1_2/ZN 0.03977f
C1153 ac_en adc_en 0.44563f
C1154 adc_refs0 adc_mux0 0.06352f
C1155 adc_dac6 rc_trim2 0.04044f
C1156 clk_rc adc_mux3 0.04548f
C1157 rc_en lv1 0.09577f
C1158 vbp adc0 0.05323f
C1159 ac_out rv328_glue_0/rv328_glue_p0_0/gf180mcu_fd_sc_mcu9t5v0__nor2_1_1/ZN 0.01762f
C1160 ac_en adc3 0.04044f
C1161 amx adc_mux2 0.05667f
C1162 bod_level1 rc_trim1 0.04044f
C1163 en_avcc xo_en 0.02044f
C1164 cmpa en_avcc 7.31367f
C1165 adc_en por_n 0.04044f
C1166 rc_trim3 rc_trim0 0.04122f
C1167 rv328_glue_0/rv328_glue_p0_0/gf180mcu_fd_sc_mcu9t5v0__inv_1_3/I ac_en 0.02487f
C1168 adc_mux1 adc_mux2 56.4723f
C1169 rv328_glue_0/rv328_glue_p0_0/gf180mcu_fd_sc_mcu9t5v0__inv_1_7/I rv328_glue_0/rv328_glue_p0_0/gf180mcu_fd_sc_mcu9t5v0__inv_1_8/ZN 0
C1170 adc_cmp xo_en 0.01896f
C1171 adc_cmp cmpa 0.12776f
C1172 adc_dac2 adc_dac1 40.8774f
C1173 rv328_glue_0/rv328_glue_p0_0/gf180mcu_fd_sc_mcu9t5v0__nand2_1_7/ZN rv328_glue_0/rv328_glue_p0_0/gf180mcu_fd_sc_mcu9t5v0__inv_1_8/ZN 0.02811f
C1174 rc_trim6 rc_trim2 0.04088f
C1175 rc_trim2 adc_dac7 0.04044f
C1176 adc_dac5 bod_level2 0.04804f
C1177 rc_trim7 adc_mux0 0.04044f
C1178 adc_en amx 0.1129f
C1179 acm adc_mux0 0
C1180 adc_dac6 rc_trim6 0.04044f
C1181 vbp ac_out 0.14816f
C1182 adc_en adc_mux1 0.04216f
C1183 rc_trim4 adc_dac5 0.04044f
C1184 adc_dac6 adc_dac7 41.8244f
C1185 ac_bg rc_en 0.04804f
C1186 ac_out adc_dac3 0.04683f
C1187 ok rc_trim1 0.0903f
C1188 adc_refs0 en_buf 0.15252f
C1189 adc3 amx 0.05772f
C1190 adc_mux3 xo_mode0 0.04044f
C1191 ac_en clk_rc 0.09711f
C1192 adc3 adc_mux1 0.04044f
C1193 bod_level0 adc_mux3 0.04608f
C1194 vref rc_en 0.16507f
C1195 adc_dac8 adc_refs0 0.04044f
C1196 rv328_glue_0/rv328_glue_p0_0/gf180mcu_fd_sc_mcu9t5v0__nor2_1_2/a_234_573# rv328_glue_0/rv328_glue_p0_0/gf180mcu_fd_sc_mcu9t5v0__inv_1_8/I 0.00269f
C1197 adc_en rv328_glue_0/rv328_glue_p0_0/gf180mcu_fd_sc_mcu9t5v0__nor2_1_2/ZN 0.82096f
C1198 rc_trim6 adc_dac7 0.04044f
C1199 aco adc_mux0 0.04044f
C1200 bod_level1 adc_mux0 0.04044f
C1201 ac_mux_en vtemp 0.05254f
C1202 clk_rc por_n 0
C1203 rv328_glue_0/rv328_glue_p0_0/gf180mcu_fd_sc_mcu9t5v0__nand2_1_7/ZN rv328_glue_0/rv328_glue_p0_0/gf180mcu_fd_sc_mcu9t5v0__nand2_1_6/a_245_69# 0
C1204 en_avcc rv328_glue_0/rv328_glue_p0_0/gf180mcu_fd_sc_mcu9t5v0__nor2_1_1/ZN 0.02042f
C1205 smp xo_mode1 0.07216f
C1206 rv328_glue_0/rv328_glue_p0_0/gf180mcu_fd_sc_mcu9t5v0__inv_1_5/ZN cmpa 0.03495f
C1207 adc_cmp rv328_glue_0/rv328_glue_p0_0/gf180mcu_fd_sc_mcu9t5v0__nor2_1_1/ZN 0.01761f
C1208 rv328_glue_0/rv328_glue_p0_0/gf180mcu_fd_sc_mcu9t5v0__inv_1_6/ZN bod_level2 0
C1209 clk_rc amx 0.06276f
C1210 adc_dac1 rc_trim5 0.04044f
C1211 mux_en rc_trim2 0.08372f
C1212 xo_mode1 adc_dac0 0.04743f
C1213 adc_dac8 rc_trim7 0.04044f
C1214 smp rc_trim0 0.04844f
C1215 clk_rc adc_mux1 0.04548f
C1216 mux_en rv328_glue_0/rv328_glue_p0_0/gf180mcu_fd_sc_mcu9t5v0__inv_1_8/I 0.01437f
C1217 bod_o adc_mux0 0.04548f
C1218 vbp en_avcc 13.7263f
C1219 ac_en xo_mode0 0.13257f
C1220 adc_dac9 avdd 1.25287f
C1221 rc_trim1 bod_level2 0.04708f
C1222 ac_bg clk_lf 0.06027f
C1223 ac_en bod_level0 0.04044f
C1224 rc_trim2 aref 0.13622f
C1225 rc_trim4 rc_trim1 0.04122f
C1226 bod_en rv328_glue_0/rv328_glue_p0_0/gf180mcu_fd_sc_mcu9t5v0__inv_1_8/ZN 0.00172f
C1227 adc_cmp vbp 0.16273f
C1228 bod_level1 en_buf 0.05903f
C1229 adc_dac1 adc_mux2 0.04044f
C1230 adc_dac5 adc_mux3 0.04044f
C1231 adc_dac6 aref 0.2369f
C1232 rc_trim0 adc_dac0 0.04608f
C1233 aref rv328_glue_0/rv328_glue_p0_0/gf180mcu_fd_sc_mcu9t5v0__inv_1_8/I 0.00187f
C1234 aco en_buf 0.04918f
C1235 vbp adc1 0.04646f
C1236 adc_cmp adc_dac3 0.04548f
C1237 ac_mux_en adc4 0.04044f
C1238 bod_level0 por_n 0.04908f
C1239 mux_en rc_trim6 0.08344f
C1240 vref clk_lf 0.06117f
C1241 ac_mux_en bg_en 0.10429f
C1242 adc_dac8 bod_level1 0.04044f
C1243 adc2 adc_mux3 0.04044f
C1244 rv328_glue_0/rv328_glue_p0_0/gf180mcu_fd_sc_mcu9t5v0__inv_1_7/I smp 0.05247f
C1245 avdd xo_en 1.30393f
C1246 cmpa avdd 2.58987f
C1247 adc_en adc_dac1 0.0913f
C1248 amx xo_mode0 0.05772f
C1249 smp rv328_glue_0/rv328_glue_p0_0/gf180mcu_fd_sc_mcu9t5v0__nand2_1_7/ZN 0.02074f
C1250 bod_en rc_trim3 0.0882f
C1251 adc6 adc_mux3 0.04044f
C1252 rc_trim6 aref 0.13622f
C1253 bod_level0 amx 0.05772f
C1254 adc_mux1 xo_mode0 0.04044f
C1255 aref adc_dac7 0.2369f
C1256 bod_level0 adc_mux1 0.04044f
C1257 adc5 ac_bg 0.043f
C1258 adc_sample clk_xa 8.06313f
C1259 adc_mux0 bod_level2 0.04548f
C1260 adc_dac8 bod_o 0
C1261 ac_en adc_dac5 0.04044f
C1262 rc_trim4 adc_mux0 0.04044f
C1263 smp rv328_glue_0/rv328_glue_p0_0/gf180mcu_fd_sc_mcu9t5v0__inv_1_4/I 0.04035f
C1264 rv328_glue_0/rv328_glue_p0_0/gf180mcu_fd_sc_mcu9t5v0__nor2_1_2/ZN xo_mode0 0
C1265 ac_mux_en adc_dac2 0.04044f
C1266 rv328_glue_0/rv328_glue_p0_0/gf180mcu_fd_sc_mcu9t5v0__nor2_1_2/a_234_573# aref 0.00153f
C1267 vref adc5 0.05254f
C1268 ac_mux_en rv328_glue_0/rv328_glue_p0_0/gf180mcu_fd_sc_mcu9t5v0__nand2_1_4/ZN 0.50781f
C1269 adc_refs0 rc_trim2 0.04044f
C1270 ac_bg acp 1.28546f
C1271 ac_en adc2 0.04044f
C1272 adc_dac2 adc_dac4 0.0426f
C1273 adc_mux3 rc_trim1 0.04044f
C1274 adc_dac6 adc_refs0 0.04044f
C1275 adc_refs0 rv328_glue_0/rv328_glue_p0_0/gf180mcu_fd_sc_mcu9t5v0__inv_1_8/I 0.01437f
C1276 ac_en adc6 0.04044f
C1277 avdd rv328_glue_0/rv328_glue_p0_0/gf180mcu_fd_sc_mcu9t5v0__nor2_1_1/ZN 0.45603f
C1278 vref acp 1.19231f
C1279 amx adc_dac5 0.04709f
C1280 lv1 rv328_glue_0/rv328_glue_p0_0/gf180mcu_fd_sc_mcu9t5v0__inv_1_8/ZN 0
C1281 mux_en aref 0.13622f
C1282 adc_mux2 clk_xa 0.04044f
C1283 en_buf bod_level2 0.10526f
C1284 adc_dac5 adc_mux1 0.04044f
C1285 adc_refs1 rc_trim3 0.0452f
C1286 ac_mux_en adc_sample 0.08983f
C1287 adc_refs0 rc_trim6 0.04044f
C1288 rc_trim2 rc_trim7 0.04072f
C1289 amx adc2 0.05772f
C1290 adc_refs0 adc_dac7 0.04044f
C1291 smp bod_en 0.13851f
C1292 adc_dac6 rc_trim7 0.04044f
C1293 vbp avdd 5.97706f
C1294 adc_en clk_xa 0.09793f
C1295 adc_sample adc_dac4 0.01053f
C1296 adc6 amx 0.05772f
C1297 adc_dac8 bod_level2 0.04804f
C1298 adc2 adc_mux1 0.04044f
C1299 adc_dac8 rc_trim4 0.04044f
C1300 vbp ain0 0.05406f
C1301 avdd adc_dac3 0.99898f
C1302 rc_trim3 lv1 0.08748f
C1303 ac_mux_en rc_trim5 0.08088f
C1304 adc6 adc_mux1 0.04044f
C1305 rv328_glue_0/rv328_glue_p0_0/gf180mcu_fd_sc_mcu9t5v0__inv_1_1/I cmpa 2.1177f
C1306 bod_en adc_dac0 0.04608f
C1307 ac_en rc_trim1 0.08344f
C1308 adc_mux0 adc_mux3 0.04122f
C1309 adc_dac1 xo_mode0 0.04044f
C1310 adc7 ac_bg 0.05164f
C1311 adc_dac4 rc_trim5 0.04044f
C1312 ac_out rv328_glue_0/rv328_glue_p0_0/gf180mcu_fd_sc_mcu9t5v0__inv_1_0/I 1.57808f
C1313 bod_level0 adc_dac1 0.04044f
C1314 rc_trim2 bod_level1 0.04044f
C1315 rc_trim6 rc_trim7 37.3832f
C1316 adc_dac6 bod_level1 0.04044f
C1317 adc_dac6 aco 0.01213f
C1318 rc_trim7 adc_dac7 0.04044f
C1319 aco rv328_glue_0/rv328_glue_p0_0/gf180mcu_fd_sc_mcu9t5v0__inv_1_8/I 0.01437f
C1320 bod_level1 rv328_glue_0/rv328_glue_p0_0/gf180mcu_fd_sc_mcu9t5v0__inv_1_8/I 0.01442f
C1321 adc7 vref 0.06117f
C1322 ac_mux_en adc_mux2 0.04088f
C1323 adc_dac2 rc_en 0.04804f
C1324 adc0 adc1 12.0377f
C1325 vtemp adc5 0.00593f
C1326 ac_bg rc_trim3 0.043f
C1327 adc_dac4 adc_mux2 0.04044f
C1328 ac_out en_avcc 0.07915f
C1329 amx rc_trim1 0.05772f
C1330 ac_mux_en adc_en 0.11553p
C1331 mux_en adc_refs0 0.0409f
C1332 rc_trim6 bod_level1 0.04044f
C1333 clk_rc clk_xa 31.0284f
C1334 rc_trim1 adc_mux1 0.04044f
C1335 ok rc_trim2 0.08996f
C1336 adc_cmp ac_out 0.77532f
C1337 bod_level1 adc_dac7 0.04044f
C1338 adc_refs1 smp 0.08905f
C1339 adc_dac6 bod_o 0
C1340 vref rc_trim3 0.15243f
C1341 aco adc_dac7 0.01061f
C1342 rv328_glue_0/rv328_glue_p0_0/gf180mcu_fd_sc_mcu9t5v0__nor2_1_2/ZN rv328_glue_0/rv328_glue_p0_0/gf180mcu_fd_sc_mcu9t5v0__nand2_1_5/a_245_69# 0
C1343 ac_mux_en adc3 0.04044f
C1344 ac_en adc_mux0 0.04122f
C1345 adc_dac4 adc_en 0.0913f
C1346 vtemp acp 2.45633f
C1347 adc_refs0 aref 0.13818f
C1348 adc_dac9 xo_mode1 0.04655f
C1349 adc_dac5 adc_dac1 0.041f
C1350 adc_dac8 adc_mux3 0.04044f
C1351 adc_refs1 adc_dac0 0.04608f
C1352 por_n adc_mux0 0.04044f
C1353 smp lv1 0.09704f
C1354 mux_en rc_trim7 0.08344f
C1355 acm mux_en 0.04447f
C1356 ok rc_trim6 0.08959f
C1357 adc_cmp rv328_glue_0/rv328_glue_p0_0/gf180mcu_fd_sc_mcu9t5v0__inv_1_0/I 0.04406f
C1358 rc_trim5 rc_en 0.04063f
C1359 adc_dac9 rc_trim0 0.0452f
C1360 adc5 adc4 12.1615f
C1361 bod_o adc_dac7 0
C1362 xo_mode0 clk_xa 0.05771f
C1363 rc_trim7 aref 0.13622f
C1364 amx adc_mux0 0.05667f
C1365 xo_mode1 xo_en 0.17488f
C1366 cmpa xo_mode1 0.04679f
C1367 adc_mux0 adc_mux1 56.5956f
C1368 ac_mux_en clk_rc 0.09455f
C1369 bod_level0 clk_xa 0.04044f
C1370 rv328_glue_0/rv328_glue_p0_0/gf180mcu_fd_sc_mcu9t5v0__inv_1_5/ZN ac_out 0.02315f
C1371 ac_en en_buf 0.0708f
C1372 rc_trim2 bod_level2 0.04695f
C1373 mux_en bod_level1 0.05889f
C1374 rc_en adc_mux2 0.04548f
C1375 rc_trim4 rc_trim2 0.04216f
C1376 mux_en aco 0.04308f
C1377 adc_cmp en_avcc 0.07411f
C1378 rc_trim0 xo_en 0.01061f
C1379 cmpa rc_trim0 0.0452f
C1380 smp ac_bg 0.09416f
C1381 adc_dac6 bod_level2 0.04804f
C1382 rv328_glue_0/rv328_glue_p0_0/gf180mcu_fd_sc_mcu9t5v0__inv_1_8/I bod_level2 0.01441f
C1383 rc_trim4 adc_dac6 0.04044f
C1384 ac_en adc_dac8 0.04044f
C1385 adc_sample clk_lf 0
C1386 bod_level1 aref 0.13622f
C1387 aco aref 0.13799f
C1388 smp vref 0.16018f
C1389 ain1 vbp 0.05323f
C1390 adc_en rc_en 0.09352f
C1391 avdd adc0 0.76219f
C1392 ac_bg adc_dac0 0.04743f
C1393 rc_trim6 bod_level2 0.04695f
C1394 adc_dac1 rc_trim1 0.04044f
C1395 rc_trim4 rc_trim6 0.04216f
C1396 ok mux_en 49.8801f
C1397 ac_mux_en xo_mode0 0.12132f
C1398 mux_en bod_o 0.04804f
C1399 rv328_glue_0/rv328_glue_p0_0/gf180mcu_fd_sc_mcu9t5v0__inv_1_7/I cmpa 0.0144f
C1400 adc_dac7 bod_level2 0.04804f
C1401 rv328_glue_0/rv328_glue_p0_0/gf180mcu_fd_sc_mcu9t5v0__inv_1_7/I xo_en 0
C1402 rc_trim4 adc_dac7 0.04044f
C1403 adc_dac8 amx 0.04709f
C1404 ac_mux_en bod_level0 0.04044f
C1405 cmpa rv328_glue_0/rv328_glue_p0_0/gf180mcu_fd_sc_mcu9t5v0__nand2_1_7/ZN 0.02049f
C1406 xo_mode1 rv328_glue_0/rv328_glue_p0_0/gf180mcu_fd_sc_mcu9t5v0__nor2_1_1/ZN 0
C1407 xo_en rv328_glue_0/rv328_glue_p0_0/gf180mcu_fd_sc_mcu9t5v0__nand2_1_7/ZN 0.1373f
C1408 ac_out avdd 52.98794f
C1409 adc_dac4 xo_mode0 0.04044f
C1410 ok aref 0.13622f
C1411 adc_dac8 adc_mux1 0.04044f
C1412 bod_level0 adc_dac4 0.04044f
C1413 adc_refs0 rc_trim7 0.04044f
C1414 rv328_glue_0/rv328_glue_p0_0/gf180mcu_fd_sc_mcu9t5v0__inv_1_5/ZN en_avcc 0.02685f
C1415 rv328_glue_0/rv328_glue_p0_0/gf180mcu_fd_sc_mcu9t5v0__nor2_1_2/ZN en_buf 0.04215f
C1416 clk_lf adc_mux2 0.05771f
C1417 adc_cmp rv328_glue_0/rv328_glue_p0_0/gf180mcu_fd_sc_mcu9t5v0__inv_1_5/ZN 0.01911f
C1418 vbp xo_mode1 0.20228f
C1419 cmpa rv328_glue_0/rv328_glue_p0_0/gf180mcu_fd_sc_mcu9t5v0__inv_1_4/I 0.03213f
C1420 clk_rc rc_en 17.8875f
C1421 rc_trim2 adc_mux3 0.04044f
C1422 adc_dac3 xo_mode1 0.04179f
C1423 rv328_glue_0/rv328_glue_p0_0/gf180mcu_fd_sc_mcu9t5v0__nor2_1_1/a_234_573# rv328_glue_0/rv328_glue_p0_0/gf180mcu_fd_sc_mcu9t5v0__inv_1_8/ZN 0.0014f
C1424 adc_en clk_lf 0.05771f
C1425 adc_dac6 adc_mux3 0.04044f
C1426 avdd rv328_glue_0/rv328_glue_p0_0/gf180mcu_fd_sc_mcu9t5v0__inv_1_0/I 0.72353f
C1427 adc_dac1 adc_mux0 0.04044f
C1428 adc_refs0 bod_level1 0.04154f
C1429 adc_refs0 aco 0.02392f
C1430 vbp rc_trim0 0.14698f
C1431 adc_dac9 bod_en 0.0452f
C1432 mux_en bod_level2 8.10161f
C1433 rc_trim4 mux_en 0.08353f
C1434 rv328_glue_0/rv328_glue_p0_0/gf180mcu_fd_sc_mcu9t5v0__inv_1_7/I rv328_glue_0/rv328_glue_p0_0/gf180mcu_fd_sc_mcu9t5v0__nor2_1_1/ZN 0.01551f
C1435 adc_sample rv328_glue_0/rv328_glue_p0_0/gf180mcu_fd_sc_mcu9t5v0__inv_1_2/I 1.34251f
C1436 ac_mux_en adc_dac5 0.04044f
C1437 adc_dac3 rc_trim0 0.04044f
C1438 rv328_glue_0/rv328_glue_p0_0/gf180mcu_fd_sc_mcu9t5v0__nand2_1_7/ZN rv328_glue_0/rv328_glue_p0_0/gf180mcu_fd_sc_mcu9t5v0__nor2_1_1/ZN 0
C1439 avdd rv328_glue_0/rv328_glue_p0_0/gf180mcu_fd_sc_mcu9t5v0__nand2_1_7/a_245_69# 0
C1440 rc_trim6 adc_mux3 0.04044f
C1441 aref bod_level2 0.13622f
C1442 rc_trim4 aref 0.13622f
C1443 adc5 adc_mux2 0.04044f
C1444 adc_dac4 adc_dac5 41.4456f
C1445 en_avcc avdd 0.38141f
C1446 ac_mux_en adc2 0.04044f
C1447 adc_mux3 adc_dac7 0.04044f
C1448 bod_level1 rc_trim7 0.04044f
C1449 ok adc_refs0 0.04044f
C1450 cmpa bod_en 0.13539f
C1451 adc_cmp avdd 1.8347f
C1452 ac_mux_en adc6 0.04044f
C1453 bod_en xo_en 0.15718f
C1454 ac_en rc_trim2 0.08344f
C1455 avdd adc1 0.4361f
C1456 bod_level0 rc_en 0.04044f
C1457 adc_en adc5 0.04044f
C1458 ac_en adc_dac6 0.04044f
C1459 ac_en rv328_glue_0/rv328_glue_p0_0/gf180mcu_fd_sc_mcu9t5v0__inv_1_8/I 0.01452f
C1460 acp adc_mux2 0
C1461 adc_dac2 rc_trim3 0.04044f
C1462 clk_rc clk_lf 0.62672f
C1463 adc_dac8 adc_dac1 0.04062f
C1464 rv328_glue_0/rv328_glue_p0_0/gf180mcu_fd_sc_mcu9t5v0__inv_1_1/I ac_out 0.52824f
C1465 ok rc_trim7 0.08952f
C1466 aco bod_level1 0
C1467 smp rv328_glue_0/rv328_glue_p0_0/gf180mcu_fd_sc_mcu9t5v0__nand2_1_1/a_245_69# 0
C1468 adc_en acp 0.05168f
C1469 ac_en rc_trim6 0.08344f
C1470 adc_refs1 adc_dac9 0.0452f
C1471 amx rc_trim2 0.05772f
C1472 adc_en rv328_glue_0/rv328_glue_p0_0/gf180mcu_fd_sc_mcu9t5v0__inv_1_2/I 1.31815f
C1473 ac_en adc_dac7 0.04044f
C1474 rc_trim2 adc_mux1 0.04044f
C1475 ac_mux_en rc_trim1 0.08088f
C1476 adc_dac6 amx 0.04709f
C1477 smp bg_en 0.04062f
C1478 rv328_glue_0/rv328_glue_p0_0/gf180mcu_fd_sc_mcu9t5v0__nand2_1_0/a_245_69# rv328_glue_0/rv328_glue_p0_0/gf180mcu_fd_sc_mcu9t5v0__inv_1_0/I 0.0162f
C1479 adc_mux0 clk_xa 0.04044f
C1480 mux_en adc_mux3 43.3435f
C1481 adc_dac6 adc_mux1 0.04044f
C1482 rv328_glue_0/rv328_glue_p0_0/gf180mcu_fd_sc_mcu9t5v0__inv_1_5/ZN avdd 0.4514f
C1483 adc_refs0 bod_level2 0.04118f
C1484 rv328_glue_0/rv328_glue_p0_0/gf180mcu_fd_sc_mcu9t5v0__inv_1_1/I rv328_glue_0/rv328_glue_p0_0/gf180mcu_fd_sc_mcu9t5v0__inv_1_0/I 0.06074f
C1485 adc_dac4 rc_trim1 0.04044f
C1486 rc_trim4 adc_refs0 0.04044f
C1487 bod_en rv328_glue_0/rv328_glue_p0_0/gf180mcu_fd_sc_mcu9t5v0__nor2_1_1/ZN 0.14849f
C1488 rv328_glue_0/rv328_glue_p0_0/gf180mcu_fd_sc_mcu9t5v0__inv_1_3/I rv328_glue_0/rv328_glue_p0_0/gf180mcu_fd_sc_mcu9t5v0__inv_1_2/I 0.00728f
C1489 bod_o aco 0.05668f
C1490 adc_dac5 rc_en 0.04804f
C1491 ok aco 0.043f
C1492 ok bod_level1 0.04951f
C1493 adc_refs1 xo_en 0.11402f
C1494 adc_refs1 cmpa 0.08624f
C1495 rv328_glue_0/rv328_glue_p0_0/gf180mcu_fd_sc_mcu9t5v0__inv_1_5/ZN rv328_glue_0/rv328_glue_p0_0/gf180mcu_fd_sc_mcu9t5v0__nand3_1_0/a_271_69# 0.00297f
C1496 adc7 adc_mux2 0.04908f
C1497 amx rc_trim6 0.05772f
C1498 amx adc_dac7 0.04709f
C1499 rc_trim5 rc_trim3 0.04216f
C1500 rv328_glue_0/rv328_glue_p0_0/gf180mcu_fd_sc_mcu9t5v0__nor2_1_2/ZN rv328_glue_0/rv328_glue_p0_0/gf180mcu_fd_sc_mcu9t5v0__inv_1_8/I 0.08549f
C1501 rc_trim6 adc_mux1 0.04044f
C1502 adc_mux1 adc_dac7 0.04044f
C1503 vbp bod_en 0.15051f
C1504 rv328_glue_0/rv328_glue_p0_0/gf180mcu_fd_sc_mcu9t5v0__inv_1_1/I en_avcc 0
C1505 cmpa lv1 0.0944f
C1506 rv328_glue_0/rv328_glue_p0_0/gf180mcu_fd_sc_mcu9t5v0__nand2_1_0/a_245_69# adc_cmp 0
C1507 adc7 adc_en 0.04908f
C1508 smp adc_dac2 0.04608f
C1509 rc_trim7 bod_level2 0.04695f
C1510 lv1 xo_en 0.16381f
C1511 rc_trim4 rc_trim7 0.04122f
C1512 ok bod_o 0
C1513 adc_dac9 ac_bg 0.04655f
C1514 bod_en adc_dac3 0.04044f
C1515 smp rv328_glue_0/rv328_glue_p0_0/gf180mcu_fd_sc_mcu9t5v0__nand2_1_4/ZN 0.04571f
C1516 rv328_glue_0/rv328_glue_p0_0/gf180mcu_fd_sc_mcu9t5v0__inv_1_1/I adc_cmp 0.93883f
C1517 ac_mux_en adc_mux0 0.04216f
C1518 ac_en mux_en 0.16936f
C1519 rc_trim3 adc_mux2 0.04044f
C1520 adc_dac8 clk_xa 0
C1521 adc_dac2 adc_dac0 0.0426f
C1522 mux_en por_n 0.043f
C1523 adc_dac4 adc_mux0 0.04044f
C1524 ac_out xo_mode1 0
C1525 ac_en aref 0.17451f
C1526 avdd ain0 1.41076f
C1527 adc_en rc_trim3 0.08088f
C1528 aco bod_level2 0
C1529 bod_level1 bod_level2 73.94704f
C1530 avdd rv328_glue_0/rv328_glue_p0_0/gf180mcu_fd_sc_mcu9t5v0__nand3_1_0/a_271_69# 0.00109f
C1531 ac_bg xo_en 0.043f
C1532 cmpa ac_bg 0.08955f
C1533 rc_trim4 bod_level1 0.04044f
C1534 adc_refs1 rv328_glue_0/rv328_glue_p0_0/gf180mcu_fd_sc_mcu9t5v0__nor2_1_1/ZN 0.0176f
C1535 rv328_glue_0/rv328_glue_p0_0/gf180mcu_fd_sc_mcu9t5v0__nor2_1_2/ZN rv328_glue_0/rv328_glue_p0_0/gf180mcu_fd_sc_mcu9t5v0__nor2_1_2/a_234_573# 0.02957f
C1536 mux_en amx 0.13541f
C1537 smp adc_sample 0.11018f
C1538 adc_refs0 adc_mux3 1.75138f
C1539 rc_en rc_trim1 0.0534f
C1540 rc_trim2 adc_dac1 0.04044f
C1541 mux_en adc_mux1 0.10882f
C1542 vref xo_en 0.2082f
C1543 vref cmpa 0.15747f
C1544 adc_dac6 adc_dac1 0.0408f
C1545 ac_mux_en en_buf 0.04051f
C1546 smp rc_trim5 0.04844f
C1547 amx aref 19.095f
C1548 rv328_glue_0/rv328_glue_p0_0/gf180mcu_fd_sc_mcu9t5v0__inv_1_1/I rv328_glue_0/rv328_glue_p0_0/gf180mcu_fd_sc_mcu9t5v0__inv_1_5/ZN 0
C1549 lv1 rv328_glue_0/rv328_glue_p0_0/gf180mcu_fd_sc_mcu9t5v0__nor2_1_1/ZN 0.02044f
C1550 adc_refs1 vbp 0.14546f
C1551 ok bod_level2 0.05632f
C1552 ok rc_trim4 0.08971f
C1553 ac_mux_en adc_dac8 0.04044f
C1554 adc_refs1 adc_dac3 0.04044f
C1555 mux_en rv328_glue_0/rv328_glue_p0_0/gf180mcu_fd_sc_mcu9t5v0__nor2_1_2/ZN 0.04215f
C1556 rc_trim7 adc_mux3 0.04044f
C1557 rv328_glue_0/rv328_glue_p0_0/gf180mcu_fd_sc_mcu9t5v0__inv_1_7/I ac_out 0.01992f
C1558 rc_trim5 adc_dac0 0.04608f
C1559 adc_dac8 adc_dac4 0.041f
C1560 rc_trim6 adc_dac1 0.04044f
C1561 ac_out rv328_glue_0/rv328_glue_p0_0/gf180mcu_fd_sc_mcu9t5v0__nand2_1_7/ZN 0.02046f
C1562 xo_mode1 rv328_glue_0/rv328_glue_p0_0/gf180mcu_fd_sc_mcu9t5v0__nand2_1_7/a_245_69# 0
C1563 vbp lv1 0.099f
C1564 adc_dac1 adc_dac7 0.04069f
C1565 en_avcc xo_mode1 0
C1566 smp adc_mux2 0.09024f
C1567 rv328_glue_0/rv328_glue_p0_0/gf180mcu_fd_sc_mcu9t5v0__nor2_1_2/ZN aref 0.00334f
C1568 ac_en adc_refs0 0.15802f
C1569 rc_en adc_mux0 0.04548f
C1570 acm rv328_acsw_0/rv328_acsw_p0_0/gf180mcu_fd_sc_mcu9t5v0__inv_1_1/ZN 0.02799f
C1571 xo_mode0 rv328_glue_0/rv328_glue_p0_0/gf180mcu_fd_sc_mcu9t5v0__inv_1_8/ZN 0
C1572 rv328_glue_0/rv328_glue_p0_0/gf180mcu_fd_sc_mcu9t5v0__nand2_1_0/a_245_69# avdd 0
C1573 adc6 adc5 12.1925f
C1574 adc_mux2 adc_dac0 0.04608f
C1575 smp adc_en 0.42436f
C1576 bod_level1 adc_mux3 0.04608f
C1577 ac_out rv328_glue_0/rv328_glue_p0_0/gf180mcu_fd_sc_mcu9t5v0__inv_1_4/I 0.01841f
C1578 aco adc_mux3 0.04044f
C1579 rv328_glue_0/rv328_glue_p0_0/gf180mcu_fd_sc_mcu9t5v0__inv_1_1/I avdd 0.54749f
C1580 vbp ac_bg 0.05487f
C1581 adc_en adc_dac0 0.09694f
C1582 adc_refs0 amx 0.06581f
C1583 ac_en rc_trim7 0.08344f
C1584 rc_trim4 bod_level2 0.04695f
C1585 acm ac_en 0.05101f
C1586 rv328_glue_0/rv328_glue_p0_0/gf180mcu_fd_sc_mcu9t5v0__inv_1_3/I smp 0.05192f
C1587 rc_trim3 xo_mode0 0
C1588 ac_bg adc_dac3 0.04179f
C1589 adc_refs0 adc_mux1 0.06757f
C1590 vref vbp 0.11635p
C1591 bod_level0 rc_trim3 0.04044f
C1592 rv328_glue_0/rv328_glue_p0_0/gf180mcu_fd_sc_mcu9t5v0__inv_1_7/I en_avcc 0.0144f
C1593 bod_o adc_mux3 0.04548f
C1594 rv328_glue_0/rv328_glue_p0_0/gf180mcu_fd_sc_mcu9t5v0__nand2_1_7/a_245_69# rv328_glue_0/rv328_glue_p0_0/gf180mcu_fd_sc_mcu9t5v0__nand2_1_7/ZN 0.0162f
C1595 en_avcc rv328_glue_0/rv328_glue_p0_0/gf180mcu_fd_sc_mcu9t5v0__nand2_1_7/ZN 0.02051f
C1596 rv328_glue_0/rv328_glue_p0_0/gf180mcu_fd_sc_mcu9t5v0__nand2_1_2/a_245_69# rv328_glue_0/rv328_glue_p0_0/gf180mcu_fd_sc_mcu9t5v0__inv_1_2/I 0.0162f
C1597 rv328_glue_0/rv328_glue_p0_0/gf180mcu_fd_sc_mcu9t5v0__inv_1_7/I adc_cmp 0.01991f
C1598 ain1 avdd 1.41594f
C1599 adc_mux0 clk_lf 0.05771f
C1600 adc_dac8 rc_en 0.04804f
C1601 adc_cmp rv328_glue_0/rv328_glue_p0_0/gf180mcu_fd_sc_mcu9t5v0__nand2_1_7/ZN 0.02046f
C1602 smp clk_rc 0.04724f
C1603 adc_dac1 aref 0.2369f
C1604 ain1 ain0 12.74582f
C1605 adc_refs0 rv328_glue_0/rv328_glue_p0_0/gf180mcu_fd_sc_mcu9t5v0__nor2_1_2/ZN 0.03978f
C1606 ac_en bod_level1 0.31533f
C1607 ac_en aco 0.22216f
C1608 amx rc_trim7 0.05772f
C1609 acm amx 2.85701f
C1610 ac_out bod_en 0.06193f
C1611 rc_trim7 adc_mux1 0.04044f
C1612 acm adc_mux1 0
C1613 en_avcc rv328_glue_0/rv328_glue_p0_0/gf180mcu_fd_sc_mcu9t5v0__inv_1_4/I 0.0458f
C1614 aco por_n 0.05164f
C1615 adc_cmp rv328_glue_0/rv328_glue_p0_0/gf180mcu_fd_sc_mcu9t5v0__inv_1_4/I 0.01437f
C1616 ac_mux_en rc_trim2 0.08088f
C1617 cmpa rv328_glue_0/rv328_glue_p0_0/gf180mcu_fd_sc_mcu9t5v0__nand2_1_1/a_245_69# 0
C1618 adc7 adc6 12.2234f
C1619 ac_en bod_o 0.04548f
C1620 ac_mux_en adc_dac6 0.04044f
C1621 adc_dac5 rc_trim3 0.04044f
C1622 ok ac_en 0.043f
C1623 amx bod_level1 0.05772f
C1624 ac_mux_en rv328_glue_0/rv328_glue_p0_0/gf180mcu_fd_sc_mcu9t5v0__inv_1_8/I 0.01437f
C1625 amx aco 0.05772f
C1626 adc_dac4 rc_trim2 0.04044f
C1627 adc_mux3 bod_level2 0.05111f
C1628 bod_level1 adc_mux1 0.04044f
C1629 cmpa bg_en 0.04145f
C1630 rv328_glue_0/rv328_glue_p0_0/gf180mcu_fd_sc_mcu9t5v0__inv_1_7/I rv328_glue_0/rv328_glue_p0_0/gf180mcu_fd_sc_mcu9t5v0__inv_1_5/ZN 0
C1631 xo_en bg_en 0.06042f
C1632 adc_dac4 adc_dac6 0.0426f
C1633 aco adc_mux1 0.04044f
C1634 adc5 adc_mux0 0.04044f
C1635 avdd xo_mode1 57.99942f
C1636 rc_trim4 adc_mux3 0.04044f
C1637 smp xo_mode0 0.08209f
C1638 bod_o por_n 35.4626f
C1639 ok por_n 0.05164f
C1640 smp bod_level0 0.09528f
C1641 adc_dac2 adc_dac9 0.04538f
C1642 adc_dac8 clk_lf 0
C1643 ac_mux_en rc_trim6 0.08088f
C1644 xo_mode0 adc_dac0 0.04608f
C1645 ac_mux_en adc_dac7 0.04044f
C1646 avdd rc_trim0 0.54558f
C1647 rv328_glue_0/rv328_glue_p0_0/gf180mcu_fd_sc_mcu9t5v0__nor2_1_2/ZN aco 0.03449f
C1648 en_avcc bod_en 0.06937f
C1649 rv328_glue_0/rv328_glue_p0_0/gf180mcu_fd_sc_mcu9t5v0__nor2_1_2/ZN bod_level1 0.77483f
C1650 amx bod_o 0.06276f
C1651 mux_en clk_xa 0.10049f
C1652 adc_refs0 adc_dac1 0.04044f
C1653 adc_refs1 ac_out 0.04573f
C1654 vtemp vbp 0.11382f
C1655 adc_mux0 acp 0
C1656 bod_level0 adc_dac0 0.04608f
C1657 adc_dac4 rc_trim6 0.04044f
C1658 adc_cmp bod_en 0.06944f
C1659 rv328_glue_0/rv328_glue_p0_0/gf180mcu_fd_sc_mcu9t5v0__inv_1_5/ZN rv328_glue_0/rv328_glue_p0_0/gf180mcu_fd_sc_mcu9t5v0__inv_1_4/I 0.40852f
C1660 adc_dac4 adc_dac7 0.04144f
C1661 bod_o adc_mux1 0.04548f
C1662 adc_dac2 xo_en 0.04044f
C1663 aref clk_xa 0.20441f
C1664 adc_dac2 cmpa 0.14152f
C1665 ac_out lv1 0.06084f
C1666 cmpa rv328_glue_0/rv328_glue_p0_0/gf180mcu_fd_sc_mcu9t5v0__nand2_1_4/ZN 0.03315f
C1667 ac_en bod_level2 0.11645f
C1668 ac_en rc_trim4 0.08344f
C1669 adc_sample adc_dac9 0.63495f
C1670 rv328_glue_0/rv328_glue_p0_0/gf180mcu_fd_sc_mcu9t5v0__inv_1_7/I avdd 0.5239f
C1671 bg_en rv328_glue_0/rv328_glue_p0_0/gf180mcu_fd_sc_mcu9t5v0__nor2_1_1/ZN 0.86746f
C1672 rc_trim7 adc_dac1 0.04044f
C1673 rc_trim3 rc_trim1 0.04216f
C1674 ac_bg adc0 0.05109f
C1675 avdd rv328_glue_0/rv328_glue_p0_0/gf180mcu_fd_sc_mcu9t5v0__nand2_1_7/ZN 0.5028f
C1676 smp adc_dac5 0.04616f
C1677 rc_trim2 rc_en 0.05063f
C1678 adc_dac9 rc_trim5 0.0452f
C1679 rv328_glue_0/rv328_glue_p0_0/gf180mcu_fd_sc_mcu9t5v0__nor2_1_1/a_234_573# rv328_glue_0/rv328_glue_p0_0/gf180mcu_fd_sc_mcu9t5v0__nor2_1_1/ZN 0.02957f
C1680 adc_dac6 rc_en 0.04804f
C1681 vref adc0 0.20045f
C1682 ac_mux_en mux_en 0.139f
C1683 vbp adc4 0.04646f
C1684 avdd rv328_acsw_0/rv328_acsw_p0_0/gf180mcu_fd_sc_mcu9t5v0__inv_1_0/ZN 2.87609f
C1685 adc_sample cmpa 7.02024f
C1686 adc_dac5 adc_dac0 0.0408f
C1687 adc7 adc_mux0 0.04908f
C1688 amx bod_level2 0.06276f
C1689 ac_out ac_bg 0.04436f
C1690 vbp bg_en 0.24572f
C1691 adc_sample xo_en 0.01997f
C1692 rc_trim4 amx 0.05772f
C1693 adc_refs1 en_avcc 0.07439f
C1694 avdd rv328_glue_0/rv328_glue_p0_0/gf180mcu_fd_sc_mcu9t5v0__inv_1_4/I 0.78789f
C1695 adc_mux1 bod_level2 0.04548f
C1696 bod_level1 adc_dac1 0.04044f
C1697 rv328_acsw_0/rv328_acsw_p0_0/gf180mcu_fd_sc_mcu9t5v0__inv_1_0/ZN ain0 0.03618f
C1698 aco adc_dac1 0.04272f
C1699 ac_mux_en aref 0.1382f
C1700 rc_trim4 adc_mux1 0.04044f
C1701 adc_dac9 adc_mux2 0.0452f
C1702 adc_refs1 adc_cmp 0.05892f
C1703 rc_trim5 xo_en 0.0287f
C1704 vref ac_out 0.15514f
C1705 cmpa rc_trim5 0.0452f
C1706 rc_trim6 rc_en 0.04053f
C1707 adc_dac4 aref 0.2369f
C1708 rc_en adc_dac7 0.04804f
C1709 adc_refs0 clk_xa 0.05749f
C1710 en_avcc lv1 0.02189f
C1711 adc_mux0 rc_trim3 0.04044f
C1712 rv328_glue_0/rv328_glue_p0_0/gf180mcu_fd_sc_mcu9t5v0__nor2_1_2/ZN bod_level2 0.04295f
C1713 adc_dac9 adc_en 0.10742f
C1714 smp rv328_glue_0/rv328_glue_p0_0/gf180mcu_fd_sc_mcu9t5v0__inv_1_6/ZN 0.02492f
C1715 adc_cmp lv1 0.06813f
C1716 ac_en adc_mux3 0.04063f
C1717 cmpa adc_mux2 0.08564f
C1718 adc_dac2 vbp 0.04613f
C1719 adc_mux2 xo_en 0.04044f
C1720 en_buf rv328_glue_0/rv328_glue_p0_0/gf180mcu_fd_sc_mcu9t5v0__inv_1_8/ZN 0
C1721 smp rc_trim1 0.04844f
C1722 adc_dac6 clk_lf 0
C1723 adc_dac2 adc_dac3 41.0668f
C1724 avdd bod_en 2.19608f
C1725 por_n adc_mux3 0.04044f
C1726 adc_sample rv328_glue_0/rv328_glue_p0_0/gf180mcu_fd_sc_mcu9t5v0__nor2_1_1/ZN 0.01759f
C1727 adc_en cmpa 0.89716f
C1728 adc_en xo_en 0.42308f
C1729 adc_refs1 rv328_glue_0/rv328_glue_p0_0/gf180mcu_fd_sc_mcu9t5v0__inv_1_5/ZN 1.09934f
C1730 rc_trim1 adc_dac0 0.04608f
C1731 adc_cmp ac_bg 0.05164f
C1732 amx adc_mux3 0.05667f
C1733 vref en_avcc 0.04736f
C1734 mux_en rc_en 8.1033f
C1735 ac_mux_en adc_refs0 0.09094f
C1736 adc_sample vbp 0.1695f
C1737 ac_bg adc1 0.043f
C1738 rv328_glue_0/rv328_glue_p0_0/gf180mcu_fd_sc_mcu9t5v0__inv_1_3/I cmpa 0.02256f
C1739 adc_mux3 adc_mux1 0.04216f
C1740 vtemp adc0 9.15703f
C1741 clk_lf adc_dac7 0
C1742 clk_rc adc_dac9 0
C1743 rv328_glue_0/rv328_glue_p0_0/gf180mcu_fd_sc_mcu9t5v0__inv_1_5/ZN lv1 0
C1744 adc_dac8 rc_trim3 0.04044f
C1745 bod_level1 clk_xa 0.05749f
C1746 adc_cmp vref 0.1697f
C1747 adc_dac4 adc_refs0 0.04044f
C1748 aco clk_xa 0.10963f
C1749 rv328_acsw_0/rv328_acsw_p0_0/gf180mcu_fd_sc_mcu9t5v0__inv_1_1/ZN amx 0.0295f
C1750 aref rc_en 0.16664f
C1751 vref adc1 0.05254f
C1752 adc_dac1 bod_level2 0.04804f
C1753 vbp rc_trim5 0.13938f
C1754 rc_trim4 adc_dac1 0.04044f
C1755 smp adc_mux0 0.09024f
C1756 ac_en por_n 0.04044f
C1757 ac_mux_en rc_trim7 0.08088f
C1758 rc_trim5 adc_dac3 0.04044f
C1759 ac_mux_en acm 1.59062f
C1760 clk_rc xo_en 0.06635f
C1761 clk_rc cmpa 0.04327f
C1762 adc_refs1 avdd 1.40596f
C1763 adc_mux0 adc_dac0 0.04608f
C1764 adc_en rv328_glue_0/rv328_glue_p0_0/gf180mcu_fd_sc_mcu9t5v0__nor2_1_1/ZN 0.0183f
C1765 adc_dac4 rc_trim7 0.04044f
C1766 ac_en amx 0.06316f
C1767 bod_o clk_xa 0.05164f
C1768 ok clk_xa 0.10913f
C1769 vbp adc_mux2 0.04646f
C1770 adc_dac9 xo_mode0 0.0452f
C1771 ac_en adc_mux1 0.04088f
C1772 ain1 rv328_acsw_0/rv328_acsw_p0_0/gf180mcu_fd_sc_mcu9t5v0__inv_1_0/ZN 0.55311f
C1773 rv328_glue_0/rv328_glue_p0_0/gf180mcu_fd_sc_mcu9t5v0__nand2_1_4/a_245_69# avdd 0
C1774 adc_dac3 adc_mux2 0.04044f
C1775 mux_en clk_lf 0.06027f
C1776 bod_level0 adc_dac9 0.0452f
C1777 amx por_n 0.05772f
C1778 ac_mux_en bod_level1 0.08115f
C1779 avdd lv1 1.82676f
C1780 adc_en vbp 25.7027f
C1781 ac_mux_en aco 0.09278f
C1782 por_n adc_mux1 0.04044f
C1783 smp en_buf 0.14449f
C1784 adc_dac4 bod_level1 0.04044f
C1785 ac_en rv328_glue_0/rv328_glue_p0_0/gf180mcu_fd_sc_mcu9t5v0__nor2_1_2/ZN 0.27487f
C1786 rv328_glue_0/rv328_glue_p0_0/gf180mcu_fd_sc_mcu9t5v0__nor2_1_0/a_234_573# rv328_glue_0/rv328_glue_p0_0/gf180mcu_fd_sc_mcu9t5v0__nor2_1_1/ZN 0.00136f
C1787 adc_dac4 aco 0.017f
C1788 adc_en adc_dac3 0.0913f
C1789 adc3 vbp 0.04646f
C1790 cmpa xo_mode0 0.0455f
C1791 adc_refs0 rc_en 0.04804f
C1792 ac_out bg_en 0.01505f
C1793 xo_mode0 xo_en 91.78856f
C1794 xo_mode1 rv328_glue_0/rv328_glue_p0_0/gf180mcu_fd_sc_mcu9t5v0__nand2_1_7/ZN 1.84678f
C1795 amx adc_mux1 0.05667f
C1796 smp adc_dac8 0.04636f
C1797 bod_level0 cmpa 0.09067f
C1798 bod_level0 xo_en 0.04044f
C1799 ac_mux_en ok 0.04044f
C1800 adc_dac1 adc_mux3 0.04044f
C1801 ac_mux_en bod_o 0.04548f
C1802 avdd ac_bg 5.85595f
C1803 rv328_glue_0/rv328_glue_p0_0/gf180mcu_fd_sc_mcu9t5v0__inv_1_8/I rv328_glue_0/rv328_glue_p0_0/gf180mcu_fd_sc_mcu9t5v0__inv_1_8/ZN 1.30658f
C1804 clk_xa bod_level2 0.064f
C1805 adc_dac8 adc_dac0 0.04058f
C1806 mux_en adc5 0.043f
C1807 ac_bg ain0 0.82198f
C1808 vtemp adc1 0.01729f
C1809 adc_dac9 adc_dac5 0.04576f
C1810 vref avdd 9.48805f
C1811 rc_trim7 rc_en 0.04051f
C1812 clk_rc vbp 0.15982f
C1813 rc_trim2 rc_trim3 37.801f
C1814 vref ain0 0.13964f
C1815 adc_dac2 ac_out 0.04683f
C1816 adc_dac6 rc_trim3 0.04044f
C1817 mux_en acp 3.67759f
C1818 ac_out rv328_glue_0/rv328_glue_p0_0/gf180mcu_fd_sc_mcu9t5v0__nand2_1_4/ZN 0.02674f
C1819 xo_mode0 rv328_glue_0/rv328_glue_p0_0/gf180mcu_fd_sc_mcu9t5v0__nor2_1_1/ZN 0
C1820 rv328_glue_0/rv328_glue_p0_0/gf180mcu_fd_sc_mcu9t5v0__inv_1_8/I rv328_glue_0/rv328_glue_p0_0/gf180mcu_fd_sc_mcu9t5v0__nand2_1_6/a_245_69# 0.0162f
C1821 adc_dac5 xo_en 0.04044f
C1822 ac_en adc_dac1 0.04044f
C1823 cmpa adc_dac5 0.12371f
C1824 en_avcc bg_en 0.0621f
C1825 bod_level1 rc_en 0.04823f
C1826 aref rv328_glue_0/rv328_glue_p0_0/gf180mcu_fd_sc_mcu9t5v0__inv_1_2/I 0.00187f
C1827 ac_mux_en bod_level2 0.08613f
C1828 rc_trim6 rc_trim3 0.04122f
C1829 adc_cmp bg_en 0.0154f
C1830 ac_mux_en rc_trim4 0.08088f
C1831 bod_en xo_mode1 0.13772f
C1832 rc_trim3 adc_dac7 0.04044f
C1833 adc_dac4 bod_level2 0.04804f
C1834 vbp xo_mode0 0.19191f
C1835 adc_sample ac_out 0.08973f
C1836 rc_trim4 adc_dac4 0.04044f
C1837 rv328_glue_0/rv328_glue_p0_0/gf180mcu_fd_sc_mcu9t5v0__inv_1_5/ZN rv328_glue_0/rv328_glue_p0_0/gf180mcu_fd_sc_mcu9t5v0__nand3_1_0/a_455_69# 0
C1838 bod_level0 vbp 0.04646f
C1839 amx adc_dac1 0.04709f
C1840 adc_dac3 xo_mode0 0.04044f
C1841 adc_mux3 clk_xa 0.04044f
C1842 bod_en rc_trim0 0.0958f
C1843 adc_dac9 rc_trim1 0.0452f
C1844 bod_level0 adc_dac3 0.04044f
C1845 ok rc_en 18.7308f
C1846 adc7 mux_en 0.05164f
C1847 adc_dac1 adc_mux1 0.04044f
C1848 mux_en rv328_glue_0/rv328_glue_p0_0/gf180mcu_fd_sc_mcu9t5v0__inv_1_8/ZN 0
C1849 adc0 adc_mux2 0.04853f
C1850 en_avcc rv328_glue_0/rv328_glue_p0_0/gf180mcu_fd_sc_mcu9t5v0__nand2_1_4/ZN 0.02507f
C1851 adc_cmp adc_dac2 0.04548f
C1852 smp rc_trim2 0.04844f
C1853 adc_sample rv328_glue_0/rv328_glue_p0_0/gf180mcu_fd_sc_mcu9t5v0__inv_1_0/I 0
C1854 adc_en adc0 0.04853f
C1855 smp adc_dac6 0.0462f
C1856 adc_cmp rv328_glue_0/rv328_glue_p0_0/gf180mcu_fd_sc_mcu9t5v0__nand2_1_4/ZN 0.02573f
C1857 smp rv328_glue_0/rv328_glue_p0_0/gf180mcu_fd_sc_mcu9t5v0__inv_1_8/I 0.01437f
C1858 aco clk_lf 0.06891f
C1859 vtemp avdd 0.43782f
C1860 ac_out adc_mux2 0.04179f
C1861 cmpa rc_trim1 0.0452f
C1862 rv328_glue_0/rv328_glue_p0_0/gf180mcu_fd_sc_mcu9t5v0__inv_1_1/I vref 0
C1863 rv328_glue_0/rv328_glue_p0_0/gf180mcu_fd_sc_mcu9t5v0__inv_1_7/I bod_en 0
C1864 rc_trim1 xo_en 0.01213f
C1865 vtemp ain0 0.05149f
C1866 rc_trim2 adc_dac0 0.04608f
C1867 mux_en rc_trim3 0.08363f
C1868 bod_en rv328_glue_0/rv328_glue_p0_0/gf180mcu_fd_sc_mcu9t5v0__nand2_1_7/ZN 0.02046f
C1869 adc_dac6 adc_dac0 0.04069f
C1870 adc_refs0 rv328_glue_0/rv328_glue_p0_0/gf180mcu_fd_sc_mcu9t5v0__inv_1_2/I 0
C1871 adc_refs1 xo_mode1 0.09331f
C1872 avdd rv328_glue_0/rv328_glue_p0_0/gf180mcu_fd_sc_mcu9t5v0__nand3_1_0/a_455_69# 0
C1873 vbp adc_dac5 0.04613f
C1874 ac_en clk_xa 0.10049f
C1875 adc_sample en_avcc 0.09598f
C1876 ac_mux_en adc_mux3 0.04072f
C1877 aref rc_trim3 0.13622f
C1878 smp rc_trim6 0.04844f
C1879 adc_en ac_out 0.11308f
C1880 smp adc_dac7 0.04625f
C1881 adc_dac9 adc_mux0 0.0452f
C1882 ain1 ac_bg 0.10889f
C1883 adc_dac5 adc_dac3 0.0426f
C1884 adc_cmp adc_sample 36.24353f
C1885 bod_o clk_lf 0.57967f
C1886 rc_en bod_level2 0.5091f
C1887 por_n clk_xa 0.26702f
C1888 rc_trim4 rc_en 0.04072f
C1889 vbp adc2 0.04646f
C1890 adc_dac4 adc_mux3 0.04044f
C1891 adc_refs1 rc_trim0 0.0528f
C1892 avdd rv328_glue_0/rv328_glue_p0_0/gf180mcu_fd_sc_mcu9t5v0__nand2_1_1/a_245_69# 0
C1893 rc_trim6 adc_dac0 0.04608f
C1894 acm acp 11.52014f
C1895 ac_mux_en rv328_acsw_0/rv328_acsw_p0_0/gf180mcu_fd_sc_mcu9t5v0__inv_1_1/ZN 2.15876f
C1896 lv1 xo_mode1 0.14395f
C1897 adc0 vss 2.88865f
C1898 adc1 vss 1.94457f
C1899 adc2 vss 1.95029f
C1900 adc3 vss 1.95579f
C1901 adc4 vss 1.96109f
C1902 adc5 vss 1.96619f
C1903 adc6 vss 1.97804f
C1904 adc7 vss 3.46817f
C1905 xtal2 vss 5.86142f
C1906 xtal1 vss 1.79744f
C1907 adc_dac9 vss 12.54586f
C1908 adc_dac8 vss 6.03507f
C1909 adc_dac7 vss 6.0001f
C1910 adc_dac6 vss 5.97646f
C1911 adc_dac5 vss 5.94089f
C1912 adc_dac4 vss 5.91361f
C1913 adc_dac3 vss 5.89743f
C1914 adc_dac2 vss 5.86607f
C1915 adc_dac1 vss 5.83341f
C1916 adc_dac0 vss 8.10014f
C1917 adc_mux3 vss 8.37183f
C1918 adc_mux2 vss 8.3579f
C1919 adc_mux1 vss 8.38446f
C1920 adc_mux0 vss 8.40949f
C1921 vtemp vss 6.14685f
C1922 clk_lf vss 52.74109f
C1923 bod_o vss 18.10828f
C1924 bod_level0 vss 11.05212f
C1925 por_n vss 27.26152f
C1926 clk_xa vss 25.09105f
C1927 clk_rc vss 19.52523f
C1928 rc_trim7 vss 6.39623f
C1929 rc_trim6 vss 6.41854f
C1930 rc_trim5 vss 6.44028f
C1931 rc_trim4 vss 6.46135f
C1932 rc_trim3 vss 6.48193f
C1933 rc_trim2 vss 6.48918f
C1934 rc_trim1 vss 6.49306f
C1935 rc_trim0 vss 7.02672f
C1936 rc_en vss 16.98788f
C1937 ok vss 40.54765f
C1938 vbp vss 0.25239p
C1939 aref vss 0.10559p
C1940 rv328_acsw_0/rv328_acsw_p0_0/gf180mcu_fd_sc_mcu9t5v0__inv_1_0/ZN vss 1.91874f
C1941 ac_mux_en vss 21.91256f
C1942 ain0 vss 4.24847f
C1943 acp vss 19.89145f
C1944 rv328_acsw_0/rv328_acsw_p0_0/gf180mcu_fd_sc_mcu9t5v0__inv_1_1/ZN vss 2.03867f
C1945 vref vss 0.12582p
C1946 ac_bg vss 48.82978f
C1947 ain1 vss 4.31056f
C1948 acm vss 10.42192f
C1949 amx vss 73.11813f
C1950 avdd vss 0.52236p
C1951 rv328_glue_0/rv328_glue_p0_0/gf180mcu_fd_sc_mcu9t5v0__nor2_1_1/a_234_573# vss 0 ; **FLOATING
C1952 bod_level2 vss 16.6287f
C1953 bod_level1 vss 12.16568f
C1954 rv328_glue_0/rv328_glue_p0_0/gf180mcu_fd_sc_mcu9t5v0__nor2_1_0/a_234_573# vss 0 ; **FLOATING
C1955 rv328_glue_0/rv328_glue_p0_0/gf180mcu_fd_sc_mcu9t5v0__inv_1_4/I vss 0.98296f
C1956 adc_refs0 vss 17.43025f
C1957 rv328_glue_0/rv328_glue_p0_0/gf180mcu_fd_sc_mcu9t5v0__nand3_1_1/a_455_69# vss 0.0135f ; **FLOATING
C1958 rv328_glue_0/rv328_glue_p0_0/gf180mcu_fd_sc_mcu9t5v0__nand3_1_1/a_271_69# vss 0.01255f ; **FLOATING
C1959 rv328_glue_0/rv328_glue_p0_0/gf180mcu_fd_sc_mcu9t5v0__nand3_1_0/a_455_69# vss 0.01384f ; **FLOATING
C1960 rv328_glue_0/rv328_glue_p0_0/gf180mcu_fd_sc_mcu9t5v0__nand3_1_0/a_271_69# vss 0.01181f ; **FLOATING
C1961 rv328_glue_0/rv328_glue_p0_0/gf180mcu_fd_sc_mcu9t5v0__inv_1_8/ZN vss 1.0371f
C1962 lv1 vss 21.07916f
C1963 rv328_glue_0/rv328_glue_p0_0/gf180mcu_fd_sc_mcu9t5v0__inv_1_7/I vss 1.19125f
C1964 rv328_glue_0/rv328_glue_p0_0/gf180mcu_fd_sc_mcu9t5v0__inv_1_6/ZN vss 0.82089f
C1965 rv328_glue_0/rv328_glue_p0_0/gf180mcu_fd_sc_mcu9t5v0__inv_1_5/ZN vss 1.06129f
C1966 adc_refs1 vss 13.95339f
C1967 en_buf vss 22.19574f
C1968 en_avcc vss 15.86915f
C1969 rv328_glue_0/rv328_glue_p0_0/gf180mcu_fd_sc_mcu9t5v0__inv_1_3/I vss 1.35372f
C1970 adc_cmp vss 24.32505f
C1971 rv328_glue_0/rv328_glue_p0_0/gf180mcu_fd_sc_mcu9t5v0__inv_1_1/I vss 1.10362f
C1972 smp vss 85.85616f
C1973 ac_out vss 13.92719f
C1974 xo_mode1 vss 24.06199f
C1975 xo_mode0 vss 14.71628f
C1976 rv328_glue_0/rv328_glue_p0_0/gf180mcu_fd_sc_mcu9t5v0__nand2_1_7/a_245_69# vss 0.0105f ; **FLOATING
C1977 rv328_glue_0/rv328_glue_p0_0/gf180mcu_fd_sc_mcu9t5v0__inv_1_8/I vss 1.01419f
C1978 xo_en vss 32.4239f
C1979 rv328_glue_0/rv328_glue_p0_0/gf180mcu_fd_sc_mcu9t5v0__nand2_1_7/ZN vss 1.27576f
C1980 rv328_glue_0/rv328_glue_p0_0/gf180mcu_fd_sc_mcu9t5v0__nand2_1_6/a_245_69# vss 0.0105f ; **FLOATING
C1981 bg_en vss 15.32733f
C1982 rv328_glue_0/rv328_glue_p0_0/gf180mcu_fd_sc_mcu9t5v0__nor2_1_1/ZN vss 0.89674f
C1983 rv328_glue_0/rv328_glue_p0_0/gf180mcu_fd_sc_mcu9t5v0__nand2_1_5/a_245_69# vss 0.01034f ; **FLOATING
C1984 rv328_glue_0/rv328_glue_p0_0/gf180mcu_fd_sc_mcu9t5v0__nand2_1_4/ZN vss 1.03599f
C1985 ac_en vss 75.75102f
C1986 rv328_glue_0/rv328_glue_p0_0/gf180mcu_fd_sc_mcu9t5v0__nand2_1_4/a_245_69# vss 0.01039f ; **FLOATING
C1987 mux_en vss 24.03171f
C1988 rv328_glue_0/rv328_glue_p0_0/gf180mcu_fd_sc_mcu9t5v0__nand2_1_3/a_245_69# vss 0.01022f ; **FLOATING
C1989 rv328_glue_0/rv328_glue_p0_0/gf180mcu_fd_sc_mcu9t5v0__inv_1_2/I vss 1.17284f
C1990 adc_sample vss 28.52473f
C1991 rv328_glue_0/rv328_glue_p0_0/gf180mcu_fd_sc_mcu9t5v0__nand2_1_2/a_245_69# vss 0.01047f ; **FLOATING
C1992 cmpa vss 40.32091f
C1993 rv328_glue_0/rv328_glue_p0_0/gf180mcu_fd_sc_mcu9t5v0__nand2_1_1/a_245_69# vss 0.01022f ; **FLOATING
C1994 rv328_glue_0/rv328_glue_p0_0/gf180mcu_fd_sc_mcu9t5v0__inv_1_0/I vss 1.62551f
C1995 aco vss 49.55389f
C1996 rv328_glue_0/rv328_glue_p0_0/gf180mcu_fd_sc_mcu9t5v0__nand2_1_0/a_245_69# vss 0.01017f ; **FLOATING
C1997 rv328_glue_0/rv328_glue_p0_0/gf180mcu_fd_sc_mcu9t5v0__nor2_1_2/ZN vss 0.81139f
C1998 bod_en vss 52.0481f
C1999 adc_en vss 63.45851f
C2000 rv328_glue_0/rv328_glue_p0_0/gf180mcu_fd_sc_mcu9t5v0__nor2_1_2/a_234_573# vss 0.00194f ; **FLOATING
* --- the blocks
xpor avdd vss por_n rv328_por
xlf  avdd vss clk_lf rv328_lfosc
xbgr avdd vss bg_en vref vbp ok rv328_bgr
xbod avdd vss bod_en lv1 bod_level0 vref vbp ok bod_o rv328_bod
xrc avdd vss rc_en rc_trim7 rc_trim6 rc_trim5 rc_trim4 rc_trim3 rc_trim2 rc_trim1 rc_trim0 clk_rc rv328_rcosc
xxo avdd vss xo_en xo_mode1 xo_mode0 xtal1 xtal2 vbp clk_xa rv328_xosc
xts  avdd vss adc_en vbp vtemp rv328_tsens
xmux avdd vss adc7 adc6 adc5 adc4 adc3 adc2 adc1 adc0 vtemp vref adc_mux3 adc_mux2 adc_mux1 adc_mux0 mux_en amx rv328_amux
xrb  avdd vss en_buf en_avcc vref vbp aref rv328_refbuf
xfe  avdd vss amx aref smp adc_dac9 adc_dac8 adc_dac7 adc_dac6 adc_dac5 adc_dac4 adc_dac3 adc_dac2 adc_dac1 adc_dac0 vbp adc_en cmpa rv328_adcfe
xac  avdd vss acp acm aco vbp ac_en rv328_cmp mt=2
.ends
